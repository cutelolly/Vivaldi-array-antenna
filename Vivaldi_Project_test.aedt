# Ansys Electronics Desktop project, version 2022.1
materials:
  vacuum: permittivity=1
  Rogers TMM 6 (tm): permittivity=6 dielectric_loss_tangent=0.0023
  pec: conductivity=1e+30
  tongzhouxian_epoxy1: permittivity=2.2 dielectric_loss_tangent=0.02
  air: permittivity=1.0006 permeability=1.0000004
  PTFE: permittivity=2.2 dielectric_loss_tangent=0.02

design HFSSDesign_1_1 (HFSS, DrivenModal, model units mm)
variables:
  Phi_Scan = 0deg
  Theta_Scan = 0deg
geometry:
  inner = imported_body(C:\Users\zhang\Desktop\20230215162441_3830\é™„ä»¶2.CAEï¼ˆé«˜é¢‘ï¼‰ç”µç£ä»¿çœŸç™»é«˜æŒ‘æˆ˜èµ›èµ›é¢˜æ–‡ä»¶åŒ…\4. å¤§åž‹ç›¸æŽ§é˜µä»¿çœŸåˆ†æž\VivaldiUnitCell.step)
  outer [tongzhouxian_epoxy1] = imported_body(C:\Users\zhang\Desktop\20230215162441_3830\é™„ä»¶2.CAEï¼ˆé«˜é¢‘ï¼‰ç”µç£ä»¿çœŸç™»é«˜æŒ‘æˆ˜èµ›èµ›é¢˜æ–‡ä»¶åŒ…\4. å¤§åž‹ç›¸æŽ§é˜µä»¿çœŸåˆ†æž\VivaldiUnitCell.step)
  substrate [Rogers TMM 6 (tm)] = imported_body(C:\Users\zhang\Desktop\20230215162441_3830\é™„ä»¶2.CAEï¼ˆé«˜é¢‘ï¼‰ç”µç£ä»¿çœŸç™»é«˜æŒ‘æˆ˜èµ›èµ›é¢˜æ–‡ä»¶åŒ…\4. å¤§åž‹ç›¸æŽ§é˜µä»¿çœŸåˆ†æž\VivaldiUnitCell.step)
  airbox [air] = imported_body(C:\Users\zhang\Desktop\20230215162441_3830\é™„ä»¶2.CAEï¼ˆé«˜é¢‘ï¼‰ç”µç£ä»¿çœŸç™»é«˜æŒ‘æˆ˜èµ›èµ›é¢˜æ–‡ä»¶åŒ…\4. å¤§åž‹ç›¸æŽ§é˜µä»¿çœŸåˆ†æž\VivaldiUnitCell.step)
  EquationCurve1_1, EquationCurve1 = imported_body(C:\Users\zhang\Desktop\20230215162441_3830\é™„ä»¶2.CAEï¼ˆé«˜é¢‘ï¼‰ç”µç£ä»¿çœŸç™»é«˜æŒ‘æˆ˜èµ›èµ›é¢˜æ–‡ä»¶åŒ…\4. å¤§åž‹ç›¸æŽ§é˜µä»¿çœŸåˆ†æž\VivaldiUnitCell.step)
  outer.subtract(inner)
  group VivaldiUnitCell = outer, substrate, airbox, EquationCurve1_1, EquationCurve1
boundaries and excitations:
  PerfE1: Perfect E Objects=[EquationCurve1, EquationCurve1_1]
  PerfE2: Perfect E Faces=?.face(#24, #23)
  LatticePair1: Lattice Pair Faces=?.face(#69, #71) CoordSysVector{(-360, -680, 60) -> (-360, -680, 0)} ReverseV PhaseDelay=UseScanAngle Phi=Phi_Scan Theta=Theta_Scan
  LatticePair2: Lattice Pair Faces=?.face(#70, #72) CoordSysVector{(-360, -646, 60) -> (-360, -646, 0)} ReverseV PhaseDelay=UseScanAngle Phi=Phi_Scan Theta=Theta_Scan
  PerfE3: Perfect E Faces=outer.face(at (-342, -662.75, -4), at (-342, -662, -4))
  Rad1: Radiation Faces=?.face(#67)
  1: Lumped Port Faces=?.face(#25) Modes{Mode1{IntLine{(-341.125, -662.375, -8) -> (-341.625, -662.375, -8)} CharImp=Zpi RenormImp=50ohm}} Impedance=50ohm
  2: Lumped Port Faces=?.face(#26) Modes{Mode1{IntLine{(-341.125, -662.375, 0) -> (-341.625, -662.375, 0)} CharImp=Zpi RenormImp=50ohm}} Impedance=50ohm
setups:
  Setup1: HfssDrivenAuto AutoSolverSetting=Balanced Type=Interpolating
    sweep Sweep: 0.5GHz to 10GHz, 501 points;
source amplitudes:
  1:1: 1W 0deg
  2:1: 0W 0deg
radiation setups:
  3D: Infinite Sphere Theta=0deg..180deg step 2deg Phi=-180deg..180deg step 2deg
  Azimuth: Infinite Sphere Theta=90deg..90deg step 0deg Phi=-180deg..180deg step 1deg
  Elevation: Infinite Sphere Theta=-180deg..180deg step 1deg Phi=0deg..90deg step 90deg
  Infinite Sphere_3D: Infinite Sphere Theta=0deg..180deg step 2deg Phi=0deg..360deg step 2deg
reports:
  S Parameter Plot 1: dB(S(1,1)) vs Freq on Setup1 : Sweep; markers m1 at 0.785GHz, m2 at 9.107GHz, m3 at 4.471GHz, m4 at 7.891GHz, m5 at 6.143GHz, m6 at 6.808GHz, m7 at 1.602GHz
  S Parameter Plot 2: dB(S(2,1)), dB(S(1,2)) vs Freq on Setup1 : Sweep
  S Parameter Plot 3: dB(S(2,2)) vs Freq on Setup1 : Sweep
  Gain Plot 1: dB(GainTotal) vs Phi, Theta on Setup1 : LastAdaptive, Infinite Sphere_3D [Freq=5.25GHz]

design HFSSDesign_8_8 (HFSS, DrivenModal, model units mm)
variables:
  Phi_Scan = 0deg
  Theta_Scan = 0deg
  ScanFrequency = 4500000000Hz
  ScanAngleTheta = 0deg
  ScanAnglePhi = 0deg
  ScanPhaseShiftA = -((ScanFrequency*0.0*sin(ScanAngleTheta)*cos(ScanAnglePhi)) + (ScanFrequency*7.12587307464e-10*sin(ScanAngleTheta)*sin(ScanAnglePhi))) rad
  ScanPhaseShiftB = -((ScanFrequency*7.54504207903e-10*sin(ScanAngleTheta)*cos(ScanAnglePhi)) + (ScanFrequency*0.0*sin(ScanAngleTheta)*sin(ScanAnglePhi))) rad
  ScanMag1 = 1W
  ScanPhase1 = 0deg
  ScanMag2 = 1W
  ScanPhase2 = 0deg
geometry:
  inner = imported_body(C:\Users\zhang\Desktop\20230215162441_3830\é™„ä»¶2.CAEï¼ˆé«˜é¢‘ï¼‰ç”µç£ä»¿çœŸç™»é«˜æŒ‘æˆ˜èµ›èµ›é¢˜æ–‡ä»¶åŒ…\4. å¤§åž‹ç›¸æŽ§é˜µä»¿çœŸåˆ†æž\VivaldiUnitCell.step)
  outer [tongzhouxian_epoxy1] = imported_body(C:\Users\zhang\Desktop\20230215162441_3830\é™„ä»¶2.CAEï¼ˆé«˜é¢‘ï¼‰ç”µç£ä»¿çœŸç™»é«˜æŒ‘æˆ˜èµ›èµ›é¢˜æ–‡ä»¶åŒ…\4. å¤§åž‹ç›¸æŽ§é˜µä»¿çœŸåˆ†æž\VivaldiUnitCell.step)
  substrate [Rogers TMM 6 (tm)] = imported_body(C:\Users\zhang\Desktop\20230215162441_3830\é™„ä»¶2.CAEï¼ˆé«˜é¢‘ï¼‰ç”µç£ä»¿çœŸç™»é«˜æŒ‘æˆ˜èµ›èµ›é¢˜æ–‡ä»¶åŒ…\4. å¤§åž‹ç›¸æŽ§é˜µä»¿çœŸåˆ†æž\VivaldiUnitCell.step)
  airbox [air] = imported_body(C:\Users\zhang\Desktop\20230215162441_3830\é™„ä»¶2.CAEï¼ˆé«˜é¢‘ï¼‰ç”µç£ä»¿çœŸç™»é«˜æŒ‘æˆ˜èµ›èµ›é¢˜æ–‡ä»¶åŒ…\4. å¤§åž‹ç›¸æŽ§é˜µä»¿çœŸåˆ†æž\VivaldiUnitCell.step)
  EquationCurve1_1, EquationCurve1 = imported_body(C:\Users\zhang\Desktop\20230215162441_3830\é™„ä»¶2.CAEï¼ˆé«˜é¢‘ï¼‰ç”µç£ä»¿çœŸç™»é«˜æŒ‘æˆ˜èµ›èµ›é¢˜æ–‡ä»¶åŒ…\4. å¤§åž‹ç›¸æŽ§é˜µä»¿çœŸåˆ†æž\VivaldiUnitCell.step)
  outer.subtract(inner)
  group VivaldiUnitCell = outer, substrate, airbox, EquationCurve1_1, EquationCurve1
boundaries and excitations:
  PerfE1: Perfect E Objects=[EquationCurve1, EquationCurve1_1]
  PerfE2: Perfect E Faces=?.face(#24, #23)
  LatticePair1: Lattice Pair Faces=?.face(#69, #71) CoordSysVector{(-360, -680, 60) -> (-360, -680, 0)} ReverseV PhaseDelay=UseScanAngle Phi=Phi_Scan Theta=Theta_Scan
  LatticePair2: Lattice Pair Faces=?.face(#70, #72) CoordSysVector{(-360, -646, 60) -> (-360, -646, 0)} ReverseV PhaseDelay=UseScanAngle Phi=Phi_Scan Theta=Theta_Scan
  PerfE3: Perfect E Faces=outer.face(at (-342, -662.75, -4), at (-342, -662, -4))
  Rad1: Radiation Faces=?.face(#67)
  1: Lumped Port Faces=?.face(#25) Modes{Mode1{IntLine{(-341.125, -662.375, -8) -> (-341.625, -662.375, -8)} CharImp=Zpi RenormImp=50ohm}} Impedance=50ohm
  2: Lumped Port Faces=?.face(#26) Modes{Mode1{IntLine{(-341.125, -662.375, 0) -> (-341.625, -662.375, 0)} CharImp=Zpi RenormImp=50ohm}} Impedance=50ohm
array:
  Type=Regular Name=Vivaldi_Array UseAirObjects RowPrimaryBnd=LatticePair1 ColumnPrimaryBnd=LatticePair2 RowDimension=8 ColumnDimension=8 RenderType=0 Padding=1 PostProcessRow=1 PostProcessCol=1
setups:
  Setup1: HfssDrivenAuto AutoSolverSetting=Balanced Type=Interpolating
    sweep Sweep: 0.5GHz to 10GHz, 501 points;
  ANTSolution: HfssDriven Frequency=1GHz MaxDeltaS=0.02 MaximumPasses=15 MinimumPasses=1 MinimumConvergedPasses=1 PercentRefinement=30 BasisOrder=1 PortAccuracy=2 DrivenSolverType="Direct Solver" SaveRadFieldsOnly
    sweep Sweep: 0.5GHz to 15GHz, 401 points; Type=Interpolating InterpTolerance=0.5 InterpMaxSolns=250 InterpUsePortImped=false PassivityErrorTolerance=0.0001
source amplitudes:
  1:1: 1W 0deg
  1:2..1:64, 2:1..2:64: 0W 0deg
radiation setups:
  3D: Infinite Sphere Theta=0deg..180deg step 2deg Phi=-180deg..180deg step 2deg
  Azimuth: Infinite Sphere Theta=90deg..90deg step 0deg Phi=-180deg..180deg step 1deg
  Elevation: Infinite Sphere Theta=-180deg..180deg step 1deg Phi=0deg..90deg step 90deg
  Infinite Sphere_3D: Infinite Sphere Theta=0deg..180deg step 2deg Phi=0deg..360deg step 2deg
  Infinite Sphere1: Infinite Sphere Theta=-180deg..180deg step 2deg Phi=0deg..90deg step 45deg
reports:
  S Parameter Plot 1: dB(S(1,1)) vs Freq on Setup1 : Sweep; markers m1 at 0.785GHz, m2 at 9.107GHz, m3 at 4.471GHz
  S Parameter Plot 2: dB(S(2,1)), dB(S(1,2)) vs Freq on Setup1 : Sweep
  S Parameter Plot 3: dB(S(2,2)) vs Freq on Setup1 : Sweep
  Gain Plot 1: dB(GainTotal) vs Phi, Theta on Setup1 : LastAdaptive, 3D [Freq=all]

design HFSSDesign_5_5 (HFSS, DrivenModal, model units mm)
variables:
  Phi_Scan = 0deg
  Theta_Scan = 0deg
  ScanFrequency = 7890000000Hz
  ScanAngleTheta = 90deg
  ScanAnglePhi = 0deg
  ScanPhaseShiftA = -((ScanFrequency*0.0*sin(ScanAngleTheta)*cos(ScanAnglePhi)) + (ScanFrequency*7.12587307464e-10*sin(ScanAngleTheta)*sin(ScanAnglePhi))) rad
  ScanPhaseShiftB = -((ScanFrequency*7.54504207903e-10*sin(ScanAngleTheta)*cos(ScanAnglePhi)) + (ScanFrequency*0.0*sin(ScanAngleTheta)*sin(ScanAnglePhi))) rad
  ScanMag1 = 1W
  ScanPhase1 = 0deg
  ScanMag2 = 1W
  ScanPhase2 = 0deg
geometry:
  inner = imported_body(C:\Users\zhang\Desktop\20230215162441_3830\é™„ä»¶2.CAEï¼ˆé«˜é¢‘ï¼‰ç”µç£ä»¿çœŸç™»é«˜æŒ‘æˆ˜èµ›èµ›é¢˜æ–‡ä»¶åŒ…\4. å¤§åž‹ç›¸æŽ§é˜µä»¿çœŸåˆ†æž\VivaldiUnitCell.step)
  outer [tongzhouxian_epoxy1] = imported_body(C:\Users\zhang\Desktop\20230215162441_3830\é™„ä»¶2.CAEï¼ˆé«˜é¢‘ï¼‰ç”µç£ä»¿çœŸç™»é«˜æŒ‘æˆ˜èµ›èµ›é¢˜æ–‡ä»¶åŒ…\4. å¤§åž‹ç›¸æŽ§é˜µä»¿çœŸåˆ†æž\VivaldiUnitCell.step)
  substrate [Rogers TMM 6 (tm)] = imported_body(C:\Users\zhang\Desktop\20230215162441_3830\é™„ä»¶2.CAEï¼ˆé«˜é¢‘ï¼‰ç”µç£ä»¿çœŸç™»é«˜æŒ‘æˆ˜èµ›èµ›é¢˜æ–‡ä»¶åŒ…\4. å¤§åž‹ç›¸æŽ§é˜µä»¿çœŸåˆ†æž\VivaldiUnitCell.step)
  airbox [air] = imported_body(C:\Users\zhang\Desktop\20230215162441_3830\é™„ä»¶2.CAEï¼ˆé«˜é¢‘ï¼‰ç”µç£ä»¿çœŸç™»é«˜æŒ‘æˆ˜èµ›èµ›é¢˜æ–‡ä»¶åŒ…\4. å¤§åž‹ç›¸æŽ§é˜µä»¿çœŸåˆ†æž\VivaldiUnitCell.step)
  EquationCurve1_1, EquationCurve1 = imported_body(C:\Users\zhang\Desktop\20230215162441_3830\é™„ä»¶2.CAEï¼ˆé«˜é¢‘ï¼‰ç”µç£ä»¿çœŸç™»é«˜æŒ‘æˆ˜èµ›èµ›é¢˜æ–‡ä»¶åŒ…\4. å¤§åž‹ç›¸æŽ§é˜µä»¿çœŸåˆ†æž\VivaldiUnitCell.step)
  outer.subtract(inner)
  group VivaldiUnitCell = outer, substrate, airbox, EquationCurve1_1, EquationCurve1
boundaries and excitations:
  PerfE1: Perfect E Objects=[EquationCurve1, EquationCurve1_1]
  PerfE2: Perfect E Faces=?.face(#24, #23)
  LatticePair1: Lattice Pair Faces=?.face(#69, #71) CoordSysVector{(-360, -680, 60) -> (-360, -680, 0)} ReverseV PhaseDelay=UseScanAngle Phi=Phi_Scan Theta=Theta_Scan
  LatticePair2: Lattice Pair Faces=?.face(#70, #72) CoordSysVector{(-360, -646, 60) -> (-360, -646, 0)} ReverseV PhaseDelay=UseScanAngle Phi=Phi_Scan Theta=Theta_Scan
  PerfE3: Perfect E Faces=outer.face(at (-342, -662.75, -4), at (-342, -662, -4))
  Rad1: Radiation Faces=?.face(#67)
  1: Lumped Port Faces=?.face(#25) Modes{Mode1{IntLine{(-341.125, -662.375, -8) -> (-341.625, -662.375, -8)} CharImp=Zpi RenormImp=50ohm}} Impedance=50ohm
  2: Lumped Port Faces=?.face(#26) Modes{Mode1{IntLine{(-341.125, -662.375, 0) -> (-341.625, -662.375, 0)} CharImp=Zpi RenormImp=50ohm}} Impedance=50ohm
array:
  Type=Regular Name=A UseAirObjects RowPrimaryBnd=LatticePair1 ColumnPrimaryBnd=LatticePair2 RowDimension=5 ColumnDimension=5 RenderType=0 Padding=1 PostProcessRow=3 PostProcessCol=3
setups:
  Setup1: HfssDriven Frequency=4.5GHz MaxDeltaS=0.02 MaximumPasses=6 MinimumPasses=1 MinimumConvergedPasses=1 PercentRefinement=30 BasisOrder=1 PortAccuracy=2 DrivenSolverType="Direct Solver"
    sweep Sweep: 0.5GHz to 10GHz, 401 points; Type=Interpolating InterpTolerance=0.5 InterpMaxSolns=250 InterpUsePortImped=false PassivityErrorTolerance=0.0001
source amplitudes:
  1:1: ScanMag1*1 ScanPhase1 + (0*ScanPhaseShiftA + 0*ScanPhaseShiftB)
  1:2: ScanMag1*1 ScanPhase1 + (0*ScanPhaseShiftA + 1*ScanPhaseShiftB)
  1:3: ScanMag1*1 ScanPhase1 + (0*ScanPhaseShiftA + 2*ScanPhaseShiftB)
  1:4: ScanMag1*1 ScanPhase1 + (0*ScanPhaseShiftA + 3*ScanPhaseShiftB)
  1:5: ScanMag1*1 ScanPhase1 + (0*ScanPhaseShiftA + 4*ScanPhaseShiftB)
  1:6: ScanMag1*1 ScanPhase1 + (1*ScanPhaseShiftA + 0*ScanPhaseShiftB)
  1:7: ScanMag1*1 ScanPhase1 + (1*ScanPhaseShiftA + 1*ScanPhaseShiftB)
  1:8: ScanMag1*1 ScanPhase1 + (1*ScanPhaseShiftA + 2*ScanPhaseShiftB)
  1:9: ScanMag1*1 ScanPhase1 + (1*ScanPhaseShiftA + 3*ScanPhaseShiftB)
  1:10: ScanMag1*1 ScanPhase1 + (1*ScanPhaseShiftA + 4*ScanPhaseShiftB)
  1:11: ScanMag1*1 ScanPhase1 + (2*ScanPhaseShiftA + 0*ScanPhaseShiftB)
  1:12: ScanMag1*1 ScanPhase1 + (2*ScanPhaseShiftA + 1*ScanPhaseShiftB)
  1:13: ScanMag1*1 ScanPhase1 + (2*ScanPhaseShiftA + 2*ScanPhaseShiftB)
  1:14: ScanMag1*1 ScanPhase1 + (2*ScanPhaseShiftA + 3*ScanPhaseShiftB)
  1:15: ScanMag1*1 ScanPhase1 + (2*ScanPhaseShiftA + 4*ScanPhaseShiftB)
  1:16: ScanMag1*1 ScanPhase1 + (3*ScanPhaseShiftA + 0*ScanPhaseShiftB)
  1:17: ScanMag1*1 ScanPhase1 + (3*ScanPhaseShiftA + 1*ScanPhaseShiftB)
  1:18: ScanMag1*1 ScanPhase1 + (3*ScanPhaseShiftA + 2*ScanPhaseShiftB)
  1:19: ScanMag1*1 ScanPhase1 + (3*ScanPhaseShiftA + 3*ScanPhaseShiftB)
  1:20: ScanMag1*1 ScanPhase1 + (3*ScanPhaseShiftA + 4*ScanPhaseShiftB)
  1:21: ScanMag1*1 ScanPhase1 + (4*ScanPhaseShiftA + 0*ScanPhaseShiftB)
  1:22: ScanMag1*1 ScanPhase1 + (4*ScanPhaseShiftA + 1*ScanPhaseShiftB)
  1:23: ScanMag1*1 ScanPhase1 + (4*ScanPhaseShiftA + 2*ScanPhaseShiftB)
  1:24: ScanMag1*1 ScanPhase1 + (4*ScanPhaseShiftA + 3*ScanPhaseShiftB)
  1:25: ScanMag1*1 ScanPhase1 + (4*ScanPhaseShiftA + 4*ScanPhaseShiftB)
  2:1: ScanMag2*1 ScanPhase2 + (0*ScanPhaseShiftA + 0*ScanPhaseShiftB)
  2:2: ScanMag2*1 ScanPhase2 + (0*ScanPhaseShiftA + 1*ScanPhaseShiftB)
  2:3: ScanMag2*1 ScanPhase2 + (0*ScanPhaseShiftA + 2*ScanPhaseShiftB)
  2:4: ScanMag2*1 ScanPhase2 + (0*ScanPhaseShiftA + 3*ScanPhaseShiftB)
  2:5: ScanMag2*1 ScanPhase2 + (0*ScanPhaseShiftA + 4*ScanPhaseShiftB)
  2:6: ScanMag2*1 ScanPhase2 + (1*ScanPhaseShiftA + 0*ScanPhaseShiftB)
  2:7: ScanMag2*1 ScanPhase2 + (1*ScanPhaseShiftA + 1*ScanPhaseShiftB)
  2:8: ScanMag2*1 ScanPhase2 + (1*ScanPhaseShiftA + 2*ScanPhaseShiftB)
  2:9: ScanMag2*1 ScanPhase2 + (1*ScanPhaseShiftA + 3*ScanPhaseShiftB)
  2:10: ScanMag2*1 ScanPhase2 + (1*ScanPhaseShiftA + 4*ScanPhaseShiftB)
  2:11: ScanMag2*1 ScanPhase2 + (2*ScanPhaseShiftA + 0*ScanPhaseShiftB)
  2:12: ScanMag2*1 ScanPhase2 + (2*ScanPhaseShiftA + 1*ScanPhaseShiftB)
  2:13: ScanMag2*1 ScanPhase2 + (2*ScanPhaseShiftA + 2*ScanPhaseShiftB)
  2:14: ScanMag2*1 ScanPhase2 + (2*ScanPhaseShiftA + 3*ScanPhaseShiftB)
  2:15: ScanMag2*1 ScanPhase2 + (2*ScanPhaseShiftA + 4*ScanPhaseShiftB)
  2:16: ScanMag2*1 ScanPhase2 + (3*ScanPhaseShiftA + 0*ScanPhaseShiftB)
  2:17: ScanMag2*1 ScanPhase2 + (3*ScanPhaseShiftA + 1*ScanPhaseShiftB)
  2:18: ScanMag2*1 ScanPhase2 + (3*ScanPhaseShiftA + 2*ScanPhaseShiftB)
  2:19: ScanMag2*1 ScanPhase2 + (3*ScanPhaseShiftA + 3*ScanPhaseShiftB)
  2:20: ScanMag2*1 ScanPhase2 + (3*ScanPhaseShiftA + 4*ScanPhaseShiftB)
  2:21: ScanMag2*1 ScanPhase2 + (4*ScanPhaseShiftA + 0*ScanPhaseShiftB)
  2:22: ScanMag2*1 ScanPhase2 + (4*ScanPhaseShiftA + 1*ScanPhaseShiftB)
  2:23: ScanMag2*1 ScanPhase2 + (4*ScanPhaseShiftA + 2*ScanPhaseShiftB)
  2:24: ScanMag2*1 ScanPhase2 + (4*ScanPhaseShiftA + 3*ScanPhaseShiftB)
  2:25: ScanMag2*1 ScanPhase2 + (4*ScanPhaseShiftA + 4*ScanPhaseShiftB)
radiation setups:
  3D: Infinite Sphere Theta=0deg..180deg step 2deg Phi=-180deg..180deg step 2deg
  Azimuth: Infinite Sphere Theta=90deg..90deg step 0deg Phi=-180deg..180deg step 1deg
  Elevation: Infinite Sphere Theta=-180deg..180deg step 1deg Phi=0deg..90deg step 90deg
  Infinite Sphere_3D: Infinite Sphere Theta=0deg..180deg step 2deg Phi=0deg..360deg step 2deg
  Infinite Sphere1: Infinite Sphere Theta=-180deg..180deg step 2deg Phi=0deg..90deg step 45deg
reports:
  Gain Plot 1: dB(GainTotal) vs Phi, Theta on Setup1 : LastAdaptive, 3D [Freq=all]
  Gain Plot 2: dB(GainTotal) vs Theta, Phi on Setup1 : LastAdaptive, 3D [Freq=4.5GHz]
  Gain Plot 3: dB(GainTotal) vs Theta on Setup1 : LastAdaptive, 3D [Phi=all Freq=4.5GHz]; markers m1 at 6deg

design HFSSDesign_2_2 (HFSS, DrivenModal, model units mm)
variables:
  Phi_Scan = 0deg
  Theta_Scan = 0deg
  ScanFrequency = 4500000000Hz
  ScanAngleTheta = 45deg
  ScanAnglePhi = 90deg
  ScanPhaseShiftA = -((ScanFrequency*0.0*sin(ScanAngleTheta)*cos(ScanAnglePhi)) + (ScanFrequency*7.12587307464e-10*sin(ScanAngleTheta)*sin(ScanAnglePhi))) rad
  ScanPhaseShiftB = -((ScanFrequency*7.54504207903e-10*sin(ScanAngleTheta)*cos(ScanAnglePhi)) + (ScanFrequency*0.0*sin(ScanAngleTheta)*sin(ScanAnglePhi))) rad
  ScanMag1 = 1W
  ScanPhase1 = 0deg
  ScanMag2 = 1W
  ScanPhase2 = 0deg
geometry:
  inner = imported_body(C:\Users\zhang\Desktop\20230215162441_3830\é™„ä»¶2.CAEï¼ˆé«˜é¢‘ï¼‰ç”µç£ä»¿çœŸç™»é«˜æŒ‘æˆ˜èµ›èµ›é¢˜æ–‡ä»¶åŒ…\4. å¤§åž‹ç›¸æŽ§é˜µä»¿çœŸåˆ†æž\VivaldiUnitCell.step)
  outer [tongzhouxian_epoxy1] = imported_body(C:\Users\zhang\Desktop\20230215162441_3830\é™„ä»¶2.CAEï¼ˆé«˜é¢‘ï¼‰ç”µç£ä»¿çœŸç™»é«˜æŒ‘æˆ˜èµ›èµ›é¢˜æ–‡ä»¶åŒ…\4. å¤§åž‹ç›¸æŽ§é˜µä»¿çœŸåˆ†æž\VivaldiUnitCell.step)
  substrate [Rogers TMM 6 (tm)] = imported_body(C:\Users\zhang\Desktop\20230215162441_3830\é™„ä»¶2.CAEï¼ˆé«˜é¢‘ï¼‰ç”µç£ä»¿çœŸç™»é«˜æŒ‘æˆ˜èµ›èµ›é¢˜æ–‡ä»¶åŒ…\4. å¤§åž‹ç›¸æŽ§é˜µä»¿çœŸåˆ†æž\VivaldiUnitCell.step)
  airbox [air] = imported_body(C:\Users\zhang\Desktop\20230215162441_3830\é™„ä»¶2.CAEï¼ˆé«˜é¢‘ï¼‰ç”µç£ä»¿çœŸç™»é«˜æŒ‘æˆ˜èµ›èµ›é¢˜æ–‡ä»¶åŒ…\4. å¤§åž‹ç›¸æŽ§é˜µä»¿çœŸåˆ†æž\VivaldiUnitCell.step)
  EquationCurve1_1, EquationCurve1 = imported_body(C:\Users\zhang\Desktop\20230215162441_3830\é™„ä»¶2.CAEï¼ˆé«˜é¢‘ï¼‰ç”µç£ä»¿çœŸç™»é«˜æŒ‘æˆ˜èµ›èµ›é¢˜æ–‡ä»¶åŒ…\4. å¤§åž‹ç›¸æŽ§é˜µä»¿çœŸåˆ†æž\VivaldiUnitCell.step)
  outer.subtract(inner)
  group VivaldiUnitCell = outer, substrate, airbox, EquationCurve1_1, EquationCurve1
boundaries and excitations:
  PerfE1: Perfect E Objects=[EquationCurve1, EquationCurve1_1]
  PerfE2: Perfect E Faces=?.face(#24, #23)
  LatticePair1: Lattice Pair Faces=?.face(#69, #71) CoordSysVector{(-360, -680, 60) -> (-360, -680, 0)} ReverseV PhaseDelay=UseScanAngle Phi=Phi_Scan Theta=Theta_Scan
  LatticePair2: Lattice Pair Faces=?.face(#70, #72) CoordSysVector{(-360, -646, 60) -> (-360, -646, 0)} ReverseV PhaseDelay=UseScanAngle Phi=Phi_Scan Theta=Theta_Scan
  PerfE3: Perfect E Faces=outer.face(at (-342, -662.75, -4), at (-342, -662, -4))
  Rad1: Radiation Faces=?.face(#67)
  1: Lumped Port Faces=?.face(#25) Modes{Mode1{IntLine{(-341.125, -662.375, -8) -> (-341.625, -662.375, -8)} CharImp=Zpi RenormImp=50ohm}} Impedance=50ohm
  2: Lumped Port Faces=?.face(#26) Modes{Mode1{IntLine{(-341.125, -662.375, 0) -> (-341.625, -662.375, 0)} CharImp=Zpi RenormImp=50ohm}} Impedance=50ohm
array:
  Type=Regular Name=Test2_2 UseAirObjects RowPrimaryBnd=LatticePair1 ColumnPrimaryBnd=LatticePair2 RowDimension=2 ColumnDimension=2 RenderType=0 Padding=1 PostProcessRow=1 PostProcessCol=1
setups:
  Setup1: HfssDriven Frequency=4.5GHz MaxDeltaS=0.02 MaximumPasses=6 MinimumPasses=1 MinimumConvergedPasses=1 PercentRefinement=30 BasisOrder=1 PortAccuracy=2 DrivenSolverType="Direct Solver"
    sweep Sweep: 0.5GHz to 10GHz, 401 points; Type=Interpolating InterpTolerance=0.5 InterpMaxSolns=250 InterpUsePortImped=false PassivityErrorTolerance=0.0001
source amplitudes:
  1:1: ScanMag1*1 ScanPhase1 + (0*ScanPhaseShiftA + 0*ScanPhaseShiftB)
  1:2: ScanMag1*1 ScanPhase1 + (0*ScanPhaseShiftA + 1*ScanPhaseShiftB)
  1:3: ScanMag1*1 ScanPhase1 + (1*ScanPhaseShiftA + 0*ScanPhaseShiftB)
  1:4: ScanMag1*1 ScanPhase1 + (1*ScanPhaseShiftA + 1*ScanPhaseShiftB)
  2:1: ScanMag2*1 ScanPhase2 + (0*ScanPhaseShiftA + 0*ScanPhaseShiftB)
  2:2: ScanMag2*1 ScanPhase2 + (0*ScanPhaseShiftA + 1*ScanPhaseShiftB)
  2:3: ScanMag2*1 ScanPhase2 + (1*ScanPhaseShiftA + 0*ScanPhaseShiftB)
  2:4: ScanMag2*1 ScanPhase2 + (1*ScanPhaseShiftA + 1*ScanPhaseShiftB)
radiation setups:
  3D: Infinite Sphere Theta=0deg..180deg step 2deg Phi=-180deg..180deg step 2deg
  Azimuth: Infinite Sphere Theta=90deg..90deg step 0deg Phi=-180deg..180deg step 1deg
  Elevation: Infinite Sphere Theta=-180deg..180deg step 1deg Phi=0deg..90deg step 90deg
  Infinite Sphere_3D: Infinite Sphere Theta=0deg..180deg step 2deg Phi=0deg..360deg step 2deg
  Infinite Sphere1: Infinite Sphere Theta=-180deg..180deg step 2deg Phi=0deg..90deg step 45deg
reports:
  Gain Plot 1: dB(GainTotal) vs Phi, Theta on Setup1 : LastAdaptive, 3D [Freq=all]

design HFSSDesign_1_8 (HFSS, DrivenModal, model units mm)
variables:
  Phi_Scan = 0deg
  Theta_Scan = 0deg
  ScanFrequency = 4500000000Hz
  ScanAngleTheta = 45deg
  ScanAnglePhi = 0deg
  ScanPhaseShiftA = -((ScanFrequency*0.0*sin(ScanAngleTheta)*cos(ScanAnglePhi)) + (ScanFrequency*7.12587307464e-10*sin(ScanAngleTheta)*sin(ScanAnglePhi))) rad
  ScanPhaseShiftB = -((ScanFrequency*7.54504207903e-10*sin(ScanAngleTheta)*cos(ScanAnglePhi)) + (ScanFrequency*0.0*sin(ScanAngleTheta)*sin(ScanAnglePhi))) rad
  ScanMag1 = 1W
  ScanPhase1 = 0deg
  ScanMag2 = 1W
  ScanPhase2 = 0deg
geometry:
  inner = imported_body(C:\Users\zhang\Desktop\20230215162441_3830\é™„ä»¶2.CAEï¼ˆé«˜é¢‘ï¼‰ç”µç£ä»¿çœŸç™»é«˜æŒ‘æˆ˜èµ›èµ›é¢˜æ–‡ä»¶åŒ…\4. å¤§åž‹ç›¸æŽ§é˜µä»¿çœŸåˆ†æž\VivaldiUnitCell.step)
  outer [tongzhouxian_epoxy1] = imported_body(C:\Users\zhang\Desktop\20230215162441_3830\é™„ä»¶2.CAEï¼ˆé«˜é¢‘ï¼‰ç”µç£ä»¿çœŸç™»é«˜æŒ‘æˆ˜èµ›èµ›é¢˜æ–‡ä»¶åŒ…\4. å¤§åž‹ç›¸æŽ§é˜µä»¿çœŸåˆ†æž\VivaldiUnitCell.step)
  substrate [Rogers TMM 6 (tm)] = imported_body(C:\Users\zhang\Desktop\20230215162441_3830\é™„ä»¶2.CAEï¼ˆé«˜é¢‘ï¼‰ç”µç£ä»¿çœŸç™»é«˜æŒ‘æˆ˜èµ›èµ›é¢˜æ–‡ä»¶åŒ…\4. å¤§åž‹ç›¸æŽ§é˜µä»¿çœŸåˆ†æž\VivaldiUnitCell.step)
  airbox [air] = imported_body(C:\Users\zhang\Desktop\20230215162441_3830\é™„ä»¶2.CAEï¼ˆé«˜é¢‘ï¼‰ç”µç£ä»¿çœŸç™»é«˜æŒ‘æˆ˜èµ›èµ›é¢˜æ–‡ä»¶åŒ…\4. å¤§åž‹ç›¸æŽ§é˜µä»¿çœŸåˆ†æž\VivaldiUnitCell.step)
  EquationCurve1_1, EquationCurve1 = imported_body(C:\Users\zhang\Desktop\20230215162441_3830\é™„ä»¶2.CAEï¼ˆé«˜é¢‘ï¼‰ç”µç£ä»¿çœŸç™»é«˜æŒ‘æˆ˜èµ›èµ›é¢˜æ–‡ä»¶åŒ…\4. å¤§åž‹ç›¸æŽ§é˜µä»¿çœŸåˆ†æž\VivaldiUnitCell.step)
  outer.subtract(inner)
  group VivaldiUnitCell = outer, substrate, airbox, EquationCurve1_1, EquationCurve1
boundaries and excitations:
  PerfE1: Perfect E Objects=[EquationCurve1, EquationCurve1_1]
  PerfE2: Perfect E Faces=?.face(#24, #23)
  LatticePair1: Lattice Pair Faces=?.face(#69, #71) CoordSysVector{(-360, -680, 60) -> (-360, -680, 0)} ReverseV PhaseDelay=UseScanAngle Phi=Phi_Scan Theta=Theta_Scan
  LatticePair2: Lattice Pair Faces=?.face(#70, #72) CoordSysVector{(-360, -646, 60) -> (-360, -646, 0)} ReverseV PhaseDelay=UseScanAngle Phi=Phi_Scan Theta=Theta_Scan
  PerfE3: Perfect E Faces=outer.face(at (-342, -662.75, -4), at (-342, -662, -4))
  Rad1: Radiation Faces=?.face(#67)
  1: Lumped Port Faces=?.face(#25) Modes{Mode1{IntLine{(-341.125, -662.375, -8) -> (-341.625, -662.375, -8)} CharImp=Zpi RenormImp=50ohm}} Impedance=50ohm
  2: Lumped Port Faces=?.face(#26) Modes{Mode1{IntLine{(-341.125, -662.375, 0) -> (-341.625, -662.375, 0)} CharImp=Zpi RenormImp=50ohm}} Impedance=50ohm
array:
  Type=Regular Name=Test1_8 UseAirObjects RowPrimaryBnd=LatticePair1 ColumnPrimaryBnd=LatticePair2 RowDimension=1 ColumnDimension=8 RenderType=0 Padding=1 PostProcessRow=1 PostProcessCol=1
setups:
  Setup1: HfssDriven Frequency=4.5GHz MaxDeltaS=0.02 MaximumPasses=6 MinimumPasses=1 MinimumConvergedPasses=1 PercentRefinement=30 BasisOrder=1 PortAccuracy=2 DrivenSolverType="Direct Solver"
    sweep Sweep: 0.5GHz to 10GHz, 401 points; Type=Interpolating InterpTolerance=0.5 InterpMaxSolns=250 InterpUsePortImped=false PassivityErrorTolerance=0.0001
source amplitudes:
  1:1: ScanMag1*1 ScanPhase1 + (0*ScanPhaseShiftA + 0*ScanPhaseShiftB)
  1:2: ScanMag1*1 ScanPhase1 + (0*ScanPhaseShiftA + 1*ScanPhaseShiftB)
  1:3: ScanMag1*1 ScanPhase1 + (0*ScanPhaseShiftA + 2*ScanPhaseShiftB)
  1:4: ScanMag1*1 ScanPhase1 + (0*ScanPhaseShiftA + 3*ScanPhaseShiftB)
  1:5: ScanMag1*1 ScanPhase1 + (0*ScanPhaseShiftA + 4*ScanPhaseShiftB)
  1:6: ScanMag1*1 ScanPhase1 + (0*ScanPhaseShiftA + 5*ScanPhaseShiftB)
  1:7: ScanMag1*1 ScanPhase1 + (0*ScanPhaseShiftA + 6*ScanPhaseShiftB)
  1:8: ScanMag1*1 ScanPhase1 + (0*ScanPhaseShiftA + 7*ScanPhaseShiftB)
  2:1: ScanMag2*1 ScanPhase2 + (0*ScanPhaseShiftA + 0*ScanPhaseShiftB)
  2:2: ScanMag2*1 ScanPhase2 + (0*ScanPhaseShiftA + 1*ScanPhaseShiftB)
  2:3: ScanMag2*1 ScanPhase2 + (0*ScanPhaseShiftA + 2*ScanPhaseShiftB)
  2:4: ScanMag2*1 ScanPhase2 + (0*ScanPhaseShiftA + 3*ScanPhaseShiftB)
  2:5: ScanMag2*1 ScanPhase2 + (0*ScanPhaseShiftA + 4*ScanPhaseShiftB)
  2:6: ScanMag2*1 ScanPhase2 + (0*ScanPhaseShiftA + 5*ScanPhaseShiftB)
  2:7: ScanMag2*1 ScanPhase2 + (0*ScanPhaseShiftA + 6*ScanPhaseShiftB)
  2:8: ScanMag2*1 ScanPhase2 + (0*ScanPhaseShiftA + 7*ScanPhaseShiftB)
optimetrics:
  ParametricSetup1: Parametric Sim._Setups=[Setup1]
    sweep Theta_Scan: LIN 0deg 360deg 10deg
radiation setups:
  3D: Infinite Sphere Theta=0deg..180deg step 2deg Phi=-180deg..180deg step 2deg
  Azimuth: Infinite Sphere Theta=90deg..90deg step 0deg Phi=-180deg..180deg step 1deg
  Elevation: Infinite Sphere Theta=-180deg..180deg step 1deg Phi=0deg..90deg step 90deg
  Infinite Sphere_3D: Infinite Sphere Theta=0deg..180deg step 2deg Phi=0deg..360deg step 2deg
  Infinite Sphere1: Infinite Sphere Theta=-180deg..180deg step 2deg Phi=0deg..90deg step 45deg
  Source Group1: Source Context  Sources=#Test1_8[1,1]1:1, #Test1_8[1,1]2:1, #Test1_8[1,2]1:1, #Test1_8[1,2]2:1, #Test1_8[1,3]1:1, #Test1_8[1,3]2:1, #Test1_8[1,4]1:1, #Test1_8[1,4]2:1, #Test1_8[1,5]1:1, #Test1_8[1,5]2:1, #Test1_8[1,6]1:1, #Test1_8[1,6]2:1, #Test1_8[1,7]1:1, #Test1_8[1,7]2:1, #Test1_8[1,8]1:1, #Test1_8[1,8]2:1
reports:
  Gain Plot 1: dB(GainTotal) vs Phi, Theta on Setup1 : LastAdaptive, 3D [Freq=all]

design HFSSDesign_40_40 (HFSS, DrivenModal, model units mm)
variables:
  Phi_Scan = 0deg
  Theta_Scan = 0deg
  ScanFrequency = 4500000000Hz
  ScanAngleTheta = 90deg
  ScanAnglePhi = 0deg
  ScanPhaseShiftA = -((ScanFrequency*0.0*sin(ScanAngleTheta)*cos(ScanAnglePhi)) + (ScanFrequency*7.12587307464e-10*sin(ScanAngleTheta)*sin(ScanAnglePhi))) rad
  ScanPhaseShiftB = -((ScanFrequency*7.54504207903e-10*sin(ScanAngleTheta)*cos(ScanAnglePhi)) + (ScanFrequency*0.0*sin(ScanAngleTheta)*sin(ScanAnglePhi))) rad
  ScanMag1 = 1W
  ScanPhase1 = 0deg
  ScanMag2 = 1W
  ScanPhase2 = 0deg
geometry:
  inner = imported_body(C:\Users\zhang\Desktop\20230215162441_3830\é™„ä»¶2.CAEï¼ˆé«˜é¢‘ï¼‰ç”µç£ä»¿çœŸç™»é«˜æŒ‘æˆ˜èµ›èµ›é¢˜æ–‡ä»¶åŒ…\4. å¤§åž‹ç›¸æŽ§é˜µä»¿çœŸåˆ†æž\VivaldiUnitCell.step)
  outer [tongzhouxian_epoxy1] = imported_body(C:\Users\zhang\Desktop\20230215162441_3830\é™„ä»¶2.CAEï¼ˆé«˜é¢‘ï¼‰ç”µç£ä»¿çœŸç™»é«˜æŒ‘æˆ˜èµ›èµ›é¢˜æ–‡ä»¶åŒ…\4. å¤§åž‹ç›¸æŽ§é˜µä»¿çœŸåˆ†æž\VivaldiUnitCell.step)
  substrate [Rogers TMM 6 (tm)] = imported_body(C:\Users\zhang\Desktop\20230215162441_3830\é™„ä»¶2.CAEï¼ˆé«˜é¢‘ï¼‰ç”µç£ä»¿çœŸç™»é«˜æŒ‘æˆ˜èµ›èµ›é¢˜æ–‡ä»¶åŒ…\4. å¤§åž‹ç›¸æŽ§é˜µä»¿çœŸåˆ†æž\VivaldiUnitCell.step)
  airbox [air] = imported_body(C:\Users\zhang\Desktop\20230215162441_3830\é™„ä»¶2.CAEï¼ˆé«˜é¢‘ï¼‰ç”µç£ä»¿çœŸç™»é«˜æŒ‘æˆ˜èµ›èµ›é¢˜æ–‡ä»¶åŒ…\4. å¤§åž‹ç›¸æŽ§é˜µä»¿çœŸåˆ†æž\VivaldiUnitCell.step)
  EquationCurve1_1, EquationCurve1 = imported_body(C:\Users\zhang\Desktop\20230215162441_3830\é™„ä»¶2.CAEï¼ˆé«˜é¢‘ï¼‰ç”µç£ä»¿çœŸç™»é«˜æŒ‘æˆ˜èµ›èµ›é¢˜æ–‡ä»¶åŒ…\4. å¤§åž‹ç›¸æŽ§é˜µä»¿çœŸåˆ†æž\VivaldiUnitCell.step)
  outer.subtract(inner)
  group VivaldiUnitCell = outer, substrate, airbox, EquationCurve1_1, EquationCurve1
boundaries and excitations:
  PerfE1: Perfect E Objects=[EquationCurve1, EquationCurve1_1]
  PerfE2: Perfect E Faces=?.face(#23, #24)
  PerfE3: Perfect E Faces=outer.face(at (-342, -662.75, -4), at (-342, -662, -4))
  LatticePair1: Lattice Pair Faces=?.face(#69, #71) CoordSysVector{(-360, -680, 60) -> (-360, -680, 0)} ReverseV PhaseDelay=UseScanAngle Phi=Phi_Scan Theta=Theta_Scan
  LatticePair2: Lattice Pair Faces=?.face(#70, #72) CoordSysVector{(-360, -646, 60) -> (-360, -646, 0)} ReverseV PhaseDelay=UseScanAngle Phi=Phi_Scan Theta=Theta_Scan
  Rad1: Radiation Faces=?.face(#67)
  1: Lumped Port Faces=?.face(#25) Modes{Mode1{IntLine{(-341.125, -662.375, -8) -> (-341.625, -662.375, -8)} CharImp=Zpi RenormImp=50ohm}} Impedance=50ohm
  2: Lumped Port Faces=?.face(#26) Modes{Mode1{IntLine{(-341.125, -662.375, 0) -> (-341.625, -662.375, 0)} CharImp=Zpi RenormImp=50ohm}} Impedance=50ohm
array:
  Type=Regular Name=Vivaldi_40_40 UseAirObjects RowPrimaryBnd=LatticePair1 ColumnPrimaryBnd=LatticePair2 RowDimension=40 ColumnDimension=40 RenderType=0 Padding=1 PostProcessRow=1 PostProcessCol=1
setups:
  Setup1: HfssDriven Frequency=4.5GHz MaxDeltaS=0.02 MaximumPasses=10 MinimumPasses=1 MinimumConvergedPasses=1 PercentRefinement=30 BasisOrder=1 PortAccuracy=2 DrivenSolverType="Direct Solver"
    sweep Sweep: 0.5GHz to 10GHz, 401 points; Type=Interpolating InterpTolerance=0.5 InterpMaxSolns=250 InterpUsePortImped=false PassivityErrorTolerance=0.0001
source amplitudes:
  1:1: ScanMag1*1 ScanPhase1 + (0*ScanPhaseShiftA + 0*ScanPhaseShiftB)
  1:2: ScanMag1*1 ScanPhase1 + (0*ScanPhaseShiftA + 1*ScanPhaseShiftB)
  1:3: ScanMag1*1 ScanPhase1 + (0*ScanPhaseShiftA + 2*ScanPhaseShiftB)
  1:4: ScanMag1*1 ScanPhase1 + (0*ScanPhaseShiftA + 3*ScanPhaseShiftB)
  1:5: ScanMag1*1 ScanPhase1 + (0*ScanPhaseShiftA + 4*ScanPhaseShiftB)
  1:6: ScanMag1*1 ScanPhase1 + (0*ScanPhaseShiftA + 5*ScanPhaseShiftB)
  1:7: ScanMag1*1 ScanPhase1 + (0*ScanPhaseShiftA + 6*ScanPhaseShiftB)
  1:8: ScanMag1*1 ScanPhase1 + (0*ScanPhaseShiftA + 7*ScanPhaseShiftB)
  1:9: ScanMag1*1 ScanPhase1 + (0*ScanPhaseShiftA + 8*ScanPhaseShiftB)
  1:10: ScanMag1*1 ScanPhase1 + (0*ScanPhaseShiftA + 9*ScanPhaseShiftB)
  1:11: ScanMag1*1 ScanPhase1 + (0*ScanPhaseShiftA + 10*ScanPhaseShiftB)
  1:12: ScanMag1*1 ScanPhase1 + (0*ScanPhaseShiftA + 11*ScanPhaseShiftB)
  1:13: ScanMag1*1 ScanPhase1 + (0*ScanPhaseShiftA + 12*ScanPhaseShiftB)
  1:14: ScanMag1*1 ScanPhase1 + (0*ScanPhaseShiftA + 13*ScanPhaseShiftB)
  1:15: ScanMag1*1 ScanPhase1 + (0*ScanPhaseShiftA + 14*ScanPhaseShiftB)
  1:16: ScanMag1*1 ScanPhase1 + (0*ScanPhaseShiftA + 15*ScanPhaseShiftB)
  1:17: ScanMag1*1 ScanPhase1 + (0*ScanPhaseShiftA + 16*ScanPhaseShiftB)
  1:18: ScanMag1*1 ScanPhase1 + (0*ScanPhaseShiftA + 17*ScanPhaseShiftB)
  1:19: ScanMag1*1 ScanPhase1 + (0*ScanPhaseShiftA + 18*ScanPhaseShiftB)
  1:20: ScanMag1*1 ScanPhase1 + (0*ScanPhaseShiftA + 19*ScanPhaseShiftB)
  1:21: ScanMag1*1 ScanPhase1 + (0*ScanPhaseShiftA + 20*ScanPhaseShiftB)
  1:22: ScanMag1*1 ScanPhase1 + (0*ScanPhaseShiftA + 21*ScanPhaseShiftB)
  1:23: ScanMag1*1 ScanPhase1 + (0*ScanPhaseShiftA + 22*ScanPhaseShiftB)
  1:24: ScanMag1*1 ScanPhase1 + (0*ScanPhaseShiftA + 23*ScanPhaseShiftB)
  1:25: ScanMag1*1 ScanPhase1 + (0*ScanPhaseShiftA + 24*ScanPhaseShiftB)
  1:26: ScanMag1*1 ScanPhase1 + (0*ScanPhaseShiftA + 25*ScanPhaseShiftB)
  1:27: ScanMag1*1 ScanPhase1 + (0*ScanPhaseShiftA + 26*ScanPhaseShiftB)
  1:28: ScanMag1*1 ScanPhase1 + (0*ScanPhaseShiftA + 27*ScanPhaseShiftB)
  1:29: ScanMag1*1 ScanPhase1 + (0*ScanPhaseShiftA + 28*ScanPhaseShiftB)
  1:30: ScanMag1*1 ScanPhase1 + (0*ScanPhaseShiftA + 29*ScanPhaseShiftB)
  1:31: ScanMag1*1 ScanPhase1 + (0*ScanPhaseShiftA + 30*ScanPhaseShiftB)
  1:32: ScanMag1*1 ScanPhase1 + (0*ScanPhaseShiftA + 31*ScanPhaseShiftB)
  1:33: ScanMag1*1 ScanPhase1 + (0*ScanPhaseShiftA + 32*ScanPhaseShiftB)
  1:34: ScanMag1*1 ScanPhase1 + (0*ScanPhaseShiftA + 33*ScanPhaseShiftB)
  1:35: ScanMag1*1 ScanPhase1 + (0*ScanPhaseShiftA + 34*ScanPhaseShiftB)
  1:36: ScanMag1*1 ScanPhase1 + (0*ScanPhaseShiftA + 35*ScanPhaseShiftB)
  1:37: ScanMag1*1 ScanPhase1 + (0*ScanPhaseShiftA + 36*ScanPhaseShiftB)
  1:38: ScanMag1*1 ScanPhase1 + (0*ScanPhaseShiftA + 37*ScanPhaseShiftB)
  1:39: ScanMag1*1 ScanPhase1 + (0*ScanPhaseShiftA + 38*ScanPhaseShiftB)
  1:40: ScanMag1*1 ScanPhase1 + (0*ScanPhaseShiftA + 39*ScanPhaseShiftB)
  1:41: ScanMag1*1 ScanPhase1 + (1*ScanPhaseShiftA + 0*ScanPhaseShiftB)
  1:42: ScanMag1*1 ScanPhase1 + (1*ScanPhaseShiftA + 1*ScanPhaseShiftB)
  1:43: ScanMag1*1 ScanPhase1 + (1*ScanPhaseShiftA + 2*ScanPhaseShiftB)
  1:44: ScanMag1*1 ScanPhase1 + (1*ScanPhaseShiftA + 3*ScanPhaseShiftB)
  1:45: ScanMag1*1 ScanPhase1 + (1*ScanPhaseShiftA + 4*ScanPhaseShiftB)
  1:46: ScanMag1*1 ScanPhase1 + (1*ScanPhaseShiftA + 5*ScanPhaseShiftB)
  1:47: ScanMag1*1 ScanPhase1 + (1*ScanPhaseShiftA + 6*ScanPhaseShiftB)
  1:48: ScanMag1*1 ScanPhase1 + (1*ScanPhaseShiftA + 7*ScanPhaseShiftB)
  1:49: ScanMag1*1 ScanPhase1 + (1*ScanPhaseShiftA + 8*ScanPhaseShiftB)
  1:50: ScanMag1*1 ScanPhase1 + (1*ScanPhaseShiftA + 9*ScanPhaseShiftB)
  1:51: ScanMag1*1 ScanPhase1 + (1*ScanPhaseShiftA + 10*ScanPhaseShiftB)
  1:52: ScanMag1*1 ScanPhase1 + (1*ScanPhaseShiftA + 11*ScanPhaseShiftB)
  1:53: ScanMag1*1 ScanPhase1 + (1*ScanPhaseShiftA + 12*ScanPhaseShiftB)
  1:54: ScanMag1*1 ScanPhase1 + (1*ScanPhaseShiftA + 13*ScanPhaseShiftB)
  1:55: ScanMag1*1 ScanPhase1 + (1*ScanPhaseShiftA + 14*ScanPhaseShiftB)
  1:56: ScanMag1*1 ScanPhase1 + (1*ScanPhaseShiftA + 15*ScanPhaseShiftB)
  1:57: ScanMag1*1 ScanPhase1 + (1*ScanPhaseShiftA + 16*ScanPhaseShiftB)
  1:58: ScanMag1*1 ScanPhase1 + (1*ScanPhaseShiftA + 17*ScanPhaseShiftB)
  1:59: ScanMag1*1 ScanPhase1 + (1*ScanPhaseShiftA + 18*ScanPhaseShiftB)
  1:60: ScanMag1*1 ScanPhase1 + (1*ScanPhaseShiftA + 19*ScanPhaseShiftB)
  1:61: ScanMag1*1 ScanPhase1 + (1*ScanPhaseShiftA + 20*ScanPhaseShiftB)
  1:62: ScanMag1*1 ScanPhase1 + (1*ScanPhaseShiftA + 21*ScanPhaseShiftB)
  1:63: ScanMag1*1 ScanPhase1 + (1*ScanPhaseShiftA + 22*ScanPhaseShiftB)
  1:64: ScanMag1*1 ScanPhase1 + (1*ScanPhaseShiftA + 23*ScanPhaseShiftB)
  1:65: ScanMag1*1 ScanPhase1 + (1*ScanPhaseShiftA + 24*ScanPhaseShiftB)
  1:66: ScanMag1*1 ScanPhase1 + (1*ScanPhaseShiftA + 25*ScanPhaseShiftB)
  1:67: ScanMag1*1 ScanPhase1 + (1*ScanPhaseShiftA + 26*ScanPhaseShiftB)
  1:68: ScanMag1*1 ScanPhase1 + (1*ScanPhaseShiftA + 27*ScanPhaseShiftB)
  1:69: ScanMag1*1 ScanPhase1 + (1*ScanPhaseShiftA + 28*ScanPhaseShiftB)
  1:70: ScanMag1*1 ScanPhase1 + (1*ScanPhaseShiftA + 29*ScanPhaseShiftB)
  1:71: ScanMag1*1 ScanPhase1 + (1*ScanPhaseShiftA + 30*ScanPhaseShiftB)
  1:72: ScanMag1*1 ScanPhase1 + (1*ScanPhaseShiftA + 31*ScanPhaseShiftB)
  1:73: ScanMag1*1 ScanPhase1 + (1*ScanPhaseShiftA + 32*ScanPhaseShiftB)
  1:74: ScanMag1*1 ScanPhase1 + (1*ScanPhaseShiftA + 33*ScanPhaseShiftB)
  1:75: ScanMag1*1 ScanPhase1 + (1*ScanPhaseShiftA + 34*ScanPhaseShiftB)
  1:76: ScanMag1*1 ScanPhase1 + (1*ScanPhaseShiftA + 35*ScanPhaseShiftB)
  1:77: ScanMag1*1 ScanPhase1 + (1*ScanPhaseShiftA + 36*ScanPhaseShiftB)
  1:78: ScanMag1*1 ScanPhase1 + (1*ScanPhaseShiftA + 37*ScanPhaseShiftB)
  1:79: ScanMag1*1 ScanPhase1 + (1*ScanPhaseShiftA + 38*ScanPhaseShiftB)
  1:80: ScanMag1*1 ScanPhase1 + (1*ScanPhaseShiftA + 39*ScanPhaseShiftB)
  1:81: ScanMag1*1 ScanPhase1 + (2*ScanPhaseShiftA + 0*ScanPhaseShiftB)
  1:82: ScanMag1*1 ScanPhase1 + (2*ScanPhaseShiftA + 1*ScanPhaseShiftB)
  1:83: ScanMag1*1 ScanPhase1 + (2*ScanPhaseShiftA + 2*ScanPhaseShiftB)
  1:84: ScanMag1*1 ScanPhase1 + (2*ScanPhaseShiftA + 3*ScanPhaseShiftB)
  1:85: ScanMag1*1 ScanPhase1 + (2*ScanPhaseShiftA + 4*ScanPhaseShiftB)
  1:86: ScanMag1*1 ScanPhase1 + (2*ScanPhaseShiftA + 5*ScanPhaseShiftB)
  1:87: ScanMag1*1 ScanPhase1 + (2*ScanPhaseShiftA + 6*ScanPhaseShiftB)
  1:88: ScanMag1*1 ScanPhase1 + (2*ScanPhaseShiftA + 7*ScanPhaseShiftB)
  1:89: ScanMag1*1 ScanPhase1 + (2*ScanPhaseShiftA + 8*ScanPhaseShiftB)
  1:90: ScanMag1*1 ScanPhase1 + (2*ScanPhaseShiftA + 9*ScanPhaseShiftB)
  1:91: ScanMag1*1 ScanPhase1 + (2*ScanPhaseShiftA + 10*ScanPhaseShiftB)
  1:92: ScanMag1*1 ScanPhase1 + (2*ScanPhaseShiftA + 11*ScanPhaseShiftB)
  1:93: ScanMag1*1 ScanPhase1 + (2*ScanPhaseShiftA + 12*ScanPhaseShiftB)
  1:94: ScanMag1*1 ScanPhase1 + (2*ScanPhaseShiftA + 13*ScanPhaseShiftB)
  1:95: ScanMag1*1 ScanPhase1 + (2*ScanPhaseShiftA + 14*ScanPhaseShiftB)
  1:96: ScanMag1*1 ScanPhase1 + (2*ScanPhaseShiftA + 15*ScanPhaseShiftB)
  1:97: ScanMag1*1 ScanPhase1 + (2*ScanPhaseShiftA + 16*ScanPhaseShiftB)
  1:98: ScanMag1*1 ScanPhase1 + (2*ScanPhaseShiftA + 17*ScanPhaseShiftB)
  1:99: ScanMag1*1 ScanPhase1 + (2*ScanPhaseShiftA + 18*ScanPhaseShiftB)
  1:100: ScanMag1*1 ScanPhase1 + (2*ScanPhaseShiftA + 19*ScanPhaseShiftB)
  1:101: ScanMag1*1 ScanPhase1 + (2*ScanPhaseShiftA + 20*ScanPhaseShiftB)
  1:102: ScanMag1*1 ScanPhase1 + (2*ScanPhaseShiftA + 21*ScanPhaseShiftB)
  1:103: ScanMag1*1 ScanPhase1 + (2*ScanPhaseShiftA + 22*ScanPhaseShiftB)
  1:104: ScanMag1*1 ScanPhase1 + (2*ScanPhaseShiftA + 23*ScanPhaseShiftB)
  1:105: ScanMag1*1 ScanPhase1 + (2*ScanPhaseShiftA + 24*ScanPhaseShiftB)
  1:106: ScanMag1*1 ScanPhase1 + (2*ScanPhaseShiftA + 25*ScanPhaseShiftB)
  1:107: ScanMag1*1 ScanPhase1 + (2*ScanPhaseShiftA + 26*ScanPhaseShiftB)
  1:108: ScanMag1*1 ScanPhase1 + (2*ScanPhaseShiftA + 27*ScanPhaseShiftB)
  1:109: ScanMag1*1 ScanPhase1 + (2*ScanPhaseShiftA + 28*ScanPhaseShiftB)
  1:110: ScanMag1*1 ScanPhase1 + (2*ScanPhaseShiftA + 29*ScanPhaseShiftB)
  1:111: ScanMag1*1 ScanPhase1 + (2*ScanPhaseShiftA + 30*ScanPhaseShiftB)
  1:112: ScanMag1*1 ScanPhase1 + (2*ScanPhaseShiftA + 31*ScanPhaseShiftB)
  1:113: ScanMag1*1 ScanPhase1 + (2*ScanPhaseShiftA + 32*ScanPhaseShiftB)
  1:114: ScanMag1*1 ScanPhase1 + (2*ScanPhaseShiftA + 33*ScanPhaseShiftB)
  1:115: ScanMag1*1 ScanPhase1 + (2*ScanPhaseShiftA + 34*ScanPhaseShiftB)
  1:116: ScanMag1*1 ScanPhase1 + (2*ScanPhaseShiftA + 35*ScanPhaseShiftB)
  1:117: ScanMag1*1 ScanPhase1 + (2*ScanPhaseShiftA + 36*ScanPhaseShiftB)
  1:118: ScanMag1*1 ScanPhase1 + (2*ScanPhaseShiftA + 37*ScanPhaseShiftB)
  1:119: ScanMag1*1 ScanPhase1 + (2*ScanPhaseShiftA + 38*ScanPhaseShiftB)
  1:120: ScanMag1*1 ScanPhase1 + (2*ScanPhaseShiftA + 39*ScanPhaseShiftB)
  1:121: ScanMag1*1 ScanPhase1 + (3*ScanPhaseShiftA + 0*ScanPhaseShiftB)
  1:122: ScanMag1*1 ScanPhase1 + (3*ScanPhaseShiftA + 1*ScanPhaseShiftB)
  1:123: ScanMag1*1 ScanPhase1 + (3*ScanPhaseShiftA + 2*ScanPhaseShiftB)
  1:124: ScanMag1*1 ScanPhase1 + (3*ScanPhaseShiftA + 3*ScanPhaseShiftB)
  1:125: ScanMag1*1 ScanPhase1 + (3*ScanPhaseShiftA + 4*ScanPhaseShiftB)
  1:126: ScanMag1*1 ScanPhase1 + (3*ScanPhaseShiftA + 5*ScanPhaseShiftB)
  1:127: ScanMag1*1 ScanPhase1 + (3*ScanPhaseShiftA + 6*ScanPhaseShiftB)
  1:128: ScanMag1*1 ScanPhase1 + (3*ScanPhaseShiftA + 7*ScanPhaseShiftB)
  1:129: ScanMag1*1 ScanPhase1 + (3*ScanPhaseShiftA + 8*ScanPhaseShiftB)
  1:130: ScanMag1*1 ScanPhase1 + (3*ScanPhaseShiftA + 9*ScanPhaseShiftB)
  1:131: ScanMag1*1 ScanPhase1 + (3*ScanPhaseShiftA + 10*ScanPhaseShiftB)
  1:132: ScanMag1*1 ScanPhase1 + (3*ScanPhaseShiftA + 11*ScanPhaseShiftB)
  1:133: ScanMag1*1 ScanPhase1 + (3*ScanPhaseShiftA + 12*ScanPhaseShiftB)
  1:134: ScanMag1*1 ScanPhase1 + (3*ScanPhaseShiftA + 13*ScanPhaseShiftB)
  1:135: ScanMag1*1 ScanPhase1 + (3*ScanPhaseShiftA + 14*ScanPhaseShiftB)
  1:136: ScanMag1*1 ScanPhase1 + (3*ScanPhaseShiftA + 15*ScanPhaseShiftB)
  1:137: ScanMag1*1 ScanPhase1 + (3*ScanPhaseShiftA + 16*ScanPhaseShiftB)
  1:138: ScanMag1*1 ScanPhase1 + (3*ScanPhaseShiftA + 17*ScanPhaseShiftB)
  1:139: ScanMag1*1 ScanPhase1 + (3*ScanPhaseShiftA + 18*ScanPhaseShiftB)
  1:140: ScanMag1*1 ScanPhase1 + (3*ScanPhaseShiftA + 19*ScanPhaseShiftB)
  1:141: ScanMag1*1 ScanPhase1 + (3*ScanPhaseShiftA + 20*ScanPhaseShiftB)
  1:142: ScanMag1*1 ScanPhase1 + (3*ScanPhaseShiftA + 21*ScanPhaseShiftB)
  1:143: ScanMag1*1 ScanPhase1 + (3*ScanPhaseShiftA + 22*ScanPhaseShiftB)
  1:144: ScanMag1*1 ScanPhase1 + (3*ScanPhaseShiftA + 23*ScanPhaseShiftB)
  1:145: ScanMag1*1 ScanPhase1 + (3*ScanPhaseShiftA + 24*ScanPhaseShiftB)
  1:146: ScanMag1*1 ScanPhase1 + (3*ScanPhaseShiftA + 25*ScanPhaseShiftB)
  1:147: ScanMag1*1 ScanPhase1 + (3*ScanPhaseShiftA + 26*ScanPhaseShiftB)
  1:148: ScanMag1*1 ScanPhase1 + (3*ScanPhaseShiftA + 27*ScanPhaseShiftB)
  1:149: ScanMag1*1 ScanPhase1 + (3*ScanPhaseShiftA + 28*ScanPhaseShiftB)
  1:150: ScanMag1*1 ScanPhase1 + (3*ScanPhaseShiftA + 29*ScanPhaseShiftB)
  1:151: ScanMag1*1 ScanPhase1 + (3*ScanPhaseShiftA + 30*ScanPhaseShiftB)
  1:152: ScanMag1*1 ScanPhase1 + (3*ScanPhaseShiftA + 31*ScanPhaseShiftB)
  1:153: ScanMag1*1 ScanPhase1 + (3*ScanPhaseShiftA + 32*ScanPhaseShiftB)
  1:154: ScanMag1*1 ScanPhase1 + (3*ScanPhaseShiftA + 33*ScanPhaseShiftB)
  1:155: ScanMag1*1 ScanPhase1 + (3*ScanPhaseShiftA + 34*ScanPhaseShiftB)
  1:156: ScanMag1*1 ScanPhase1 + (3*ScanPhaseShiftA + 35*ScanPhaseShiftB)
  1:157: ScanMag1*1 ScanPhase1 + (3*ScanPhaseShiftA + 36*ScanPhaseShiftB)
  1:158: ScanMag1*1 ScanPhase1 + (3*ScanPhaseShiftA + 37*ScanPhaseShiftB)
  1:159: ScanMag1*1 ScanPhase1 + (3*ScanPhaseShiftA + 38*ScanPhaseShiftB)
  1:160: ScanMag1*1 ScanPhase1 + (3*ScanPhaseShiftA + 39*ScanPhaseShiftB)
  1:161: ScanMag1*1 ScanPhase1 + (4*ScanPhaseShiftA + 0*ScanPhaseShiftB)
  1:162: ScanMag1*1 ScanPhase1 + (4*ScanPhaseShiftA + 1*ScanPhaseShiftB)
  1:163: ScanMag1*1 ScanPhase1 + (4*ScanPhaseShiftA + 2*ScanPhaseShiftB)
  1:164: ScanMag1*1 ScanPhase1 + (4*ScanPhaseShiftA + 3*ScanPhaseShiftB)
  1:165: ScanMag1*1 ScanPhase1 + (4*ScanPhaseShiftA + 4*ScanPhaseShiftB)
  1:166: ScanMag1*1 ScanPhase1 + (4*ScanPhaseShiftA + 5*ScanPhaseShiftB)
  1:167: ScanMag1*1 ScanPhase1 + (4*ScanPhaseShiftA + 6*ScanPhaseShiftB)
  1:168: ScanMag1*1 ScanPhase1 + (4*ScanPhaseShiftA + 7*ScanPhaseShiftB)
  1:169: ScanMag1*1 ScanPhase1 + (4*ScanPhaseShiftA + 8*ScanPhaseShiftB)
  1:170: ScanMag1*1 ScanPhase1 + (4*ScanPhaseShiftA + 9*ScanPhaseShiftB)
  1:171: ScanMag1*1 ScanPhase1 + (4*ScanPhaseShiftA + 10*ScanPhaseShiftB)
  1:172: ScanMag1*1 ScanPhase1 + (4*ScanPhaseShiftA + 11*ScanPhaseShiftB)
  1:173: ScanMag1*1 ScanPhase1 + (4*ScanPhaseShiftA + 12*ScanPhaseShiftB)
  1:174: ScanMag1*1 ScanPhase1 + (4*ScanPhaseShiftA + 13*ScanPhaseShiftB)
  1:175: ScanMag1*1 ScanPhase1 + (4*ScanPhaseShiftA + 14*ScanPhaseShiftB)
  1:176: ScanMag1*1 ScanPhase1 + (4*ScanPhaseShiftA + 15*ScanPhaseShiftB)
  1:177: ScanMag1*1 ScanPhase1 + (4*ScanPhaseShiftA + 16*ScanPhaseShiftB)
  1:178: ScanMag1*1 ScanPhase1 + (4*ScanPhaseShiftA + 17*ScanPhaseShiftB)
  1:179: ScanMag1*1 ScanPhase1 + (4*ScanPhaseShiftA + 18*ScanPhaseShiftB)
  1:180: ScanMag1*1 ScanPhase1 + (4*ScanPhaseShiftA + 19*ScanPhaseShiftB)
  1:181: ScanMag1*1 ScanPhase1 + (4*ScanPhaseShiftA + 20*ScanPhaseShiftB)
  1:182: ScanMag1*1 ScanPhase1 + (4*ScanPhaseShiftA + 21*ScanPhaseShiftB)
  1:183: ScanMag1*1 ScanPhase1 + (4*ScanPhaseShiftA + 22*ScanPhaseShiftB)
  1:184: ScanMag1*1 ScanPhase1 + (4*ScanPhaseShiftA + 23*ScanPhaseShiftB)
  1:185: ScanMag1*1 ScanPhase1 + (4*ScanPhaseShiftA + 24*ScanPhaseShiftB)
  1:186: ScanMag1*1 ScanPhase1 + (4*ScanPhaseShiftA + 25*ScanPhaseShiftB)
  1:187: ScanMag1*1 ScanPhase1 + (4*ScanPhaseShiftA + 26*ScanPhaseShiftB)
  1:188: ScanMag1*1 ScanPhase1 + (4*ScanPhaseShiftA + 27*ScanPhaseShiftB)
  1:189: ScanMag1*1 ScanPhase1 + (4*ScanPhaseShiftA + 28*ScanPhaseShiftB)
  1:190: ScanMag1*1 ScanPhase1 + (4*ScanPhaseShiftA + 29*ScanPhaseShiftB)
  1:191: ScanMag1*1 ScanPhase1 + (4*ScanPhaseShiftA + 30*ScanPhaseShiftB)
  1:192: ScanMag1*1 ScanPhase1 + (4*ScanPhaseShiftA + 31*ScanPhaseShiftB)
  1:193: ScanMag1*1 ScanPhase1 + (4*ScanPhaseShiftA + 32*ScanPhaseShiftB)
  1:194: ScanMag1*1 ScanPhase1 + (4*ScanPhaseShiftA + 33*ScanPhaseShiftB)
  1:195: ScanMag1*1 ScanPhase1 + (4*ScanPhaseShiftA + 34*ScanPhaseShiftB)
  1:196: ScanMag1*1 ScanPhase1 + (4*ScanPhaseShiftA + 35*ScanPhaseShiftB)
  1:197: ScanMag1*1 ScanPhase1 + (4*ScanPhaseShiftA + 36*ScanPhaseShiftB)
  1:198: ScanMag1*1 ScanPhase1 + (4*ScanPhaseShiftA + 37*ScanPhaseShiftB)
  1:199: ScanMag1*1 ScanPhase1 + (4*ScanPhaseShiftA + 38*ScanPhaseShiftB)
  1:200: ScanMag1*1 ScanPhase1 + (4*ScanPhaseShiftA + 39*ScanPhaseShiftB)
  1:201: ScanMag1*1 ScanPhase1 + (5*ScanPhaseShiftA + 0*ScanPhaseShiftB)
  1:202: ScanMag1*1 ScanPhase1 + (5*ScanPhaseShiftA + 1*ScanPhaseShiftB)
  1:203: ScanMag1*1 ScanPhase1 + (5*ScanPhaseShiftA + 2*ScanPhaseShiftB)
  1:204: ScanMag1*1 ScanPhase1 + (5*ScanPhaseShiftA + 3*ScanPhaseShiftB)
  1:205: ScanMag1*1 ScanPhase1 + (5*ScanPhaseShiftA + 4*ScanPhaseShiftB)
  1:206: ScanMag1*1 ScanPhase1 + (5*ScanPhaseShiftA + 5*ScanPhaseShiftB)
  1:207: ScanMag1*1 ScanPhase1 + (5*ScanPhaseShiftA + 6*ScanPhaseShiftB)
  1:208: ScanMag1*1 ScanPhase1 + (5*ScanPhaseShiftA + 7*ScanPhaseShiftB)
  1:209: ScanMag1*1 ScanPhase1 + (5*ScanPhaseShiftA + 8*ScanPhaseShiftB)
  1:210: ScanMag1*1 ScanPhase1 + (5*ScanPhaseShiftA + 9*ScanPhaseShiftB)
  1:211: ScanMag1*1 ScanPhase1 + (5*ScanPhaseShiftA + 10*ScanPhaseShiftB)
  1:212: ScanMag1*1 ScanPhase1 + (5*ScanPhaseShiftA + 11*ScanPhaseShiftB)
  1:213: ScanMag1*1 ScanPhase1 + (5*ScanPhaseShiftA + 12*ScanPhaseShiftB)
  1:214: ScanMag1*1 ScanPhase1 + (5*ScanPhaseShiftA + 13*ScanPhaseShiftB)
  1:215: ScanMag1*1 ScanPhase1 + (5*ScanPhaseShiftA + 14*ScanPhaseShiftB)
  1:216: ScanMag1*1 ScanPhase1 + (5*ScanPhaseShiftA + 15*ScanPhaseShiftB)
  1:217: ScanMag1*1 ScanPhase1 + (5*ScanPhaseShiftA + 16*ScanPhaseShiftB)
  1:218: ScanMag1*1 ScanPhase1 + (5*ScanPhaseShiftA + 17*ScanPhaseShiftB)
  1:219: ScanMag1*1 ScanPhase1 + (5*ScanPhaseShiftA + 18*ScanPhaseShiftB)
  1:220: ScanMag1*1 ScanPhase1 + (5*ScanPhaseShiftA + 19*ScanPhaseShiftB)
  1:221: ScanMag1*1 ScanPhase1 + (5*ScanPhaseShiftA + 20*ScanPhaseShiftB)
  1:222: ScanMag1*1 ScanPhase1 + (5*ScanPhaseShiftA + 21*ScanPhaseShiftB)
  1:223: ScanMag1*1 ScanPhase1 + (5*ScanPhaseShiftA + 22*ScanPhaseShiftB)
  1:224: ScanMag1*1 ScanPhase1 + (5*ScanPhaseShiftA + 23*ScanPhaseShiftB)
  1:225: ScanMag1*1 ScanPhase1 + (5*ScanPhaseShiftA + 24*ScanPhaseShiftB)
  1:226: ScanMag1*1 ScanPhase1 + (5*ScanPhaseShiftA + 25*ScanPhaseShiftB)
  1:227: ScanMag1*1 ScanPhase1 + (5*ScanPhaseShiftA + 26*ScanPhaseShiftB)
  1:228: ScanMag1*1 ScanPhase1 + (5*ScanPhaseShiftA + 27*ScanPhaseShiftB)
  1:229: ScanMag1*1 ScanPhase1 + (5*ScanPhaseShiftA + 28*ScanPhaseShiftB)
  1:230: ScanMag1*1 ScanPhase1 + (5*ScanPhaseShiftA + 29*ScanPhaseShiftB)
  1:231: ScanMag1*1 ScanPhase1 + (5*ScanPhaseShiftA + 30*ScanPhaseShiftB)
  1:232: ScanMag1*1 ScanPhase1 + (5*ScanPhaseShiftA + 31*ScanPhaseShiftB)
  1:233: ScanMag1*1 ScanPhase1 + (5*ScanPhaseShiftA + 32*ScanPhaseShiftB)
  1:234: ScanMag1*1 ScanPhase1 + (5*ScanPhaseShiftA + 33*ScanPhaseShiftB)
  1:235: ScanMag1*1 ScanPhase1 + (5*ScanPhaseShiftA + 34*ScanPhaseShiftB)
  1:236: ScanMag1*1 ScanPhase1 + (5*ScanPhaseShiftA + 35*ScanPhaseShiftB)
  1:237: ScanMag1*1 ScanPhase1 + (5*ScanPhaseShiftA + 36*ScanPhaseShiftB)
  1:238: ScanMag1*1 ScanPhase1 + (5*ScanPhaseShiftA + 37*ScanPhaseShiftB)
  1:239: ScanMag1*1 ScanPhase1 + (5*ScanPhaseShiftA + 38*ScanPhaseShiftB)
  1:240: ScanMag1*1 ScanPhase1 + (5*ScanPhaseShiftA + 39*ScanPhaseShiftB)
  1:241: ScanMag1*1 ScanPhase1 + (6*ScanPhaseShiftA + 0*ScanPhaseShiftB)
  1:242: ScanMag1*1 ScanPhase1 + (6*ScanPhaseShiftA + 1*ScanPhaseShiftB)
  1:243: ScanMag1*1 ScanPhase1 + (6*ScanPhaseShiftA + 2*ScanPhaseShiftB)
  1:244: ScanMag1*1 ScanPhase1 + (6*ScanPhaseShiftA + 3*ScanPhaseShiftB)
  1:245: ScanMag1*1 ScanPhase1 + (6*ScanPhaseShiftA + 4*ScanPhaseShiftB)
  1:246: ScanMag1*1 ScanPhase1 + (6*ScanPhaseShiftA + 5*ScanPhaseShiftB)
  1:247: ScanMag1*1 ScanPhase1 + (6*ScanPhaseShiftA + 6*ScanPhaseShiftB)
  1:248: ScanMag1*1 ScanPhase1 + (6*ScanPhaseShiftA + 7*ScanPhaseShiftB)
  1:249: ScanMag1*1 ScanPhase1 + (6*ScanPhaseShiftA + 8*ScanPhaseShiftB)
  1:250: ScanMag1*1 ScanPhase1 + (6*ScanPhaseShiftA + 9*ScanPhaseShiftB)
  1:251: ScanMag1*1 ScanPhase1 + (6*ScanPhaseShiftA + 10*ScanPhaseShiftB)
  1:252: ScanMag1*1 ScanPhase1 + (6*ScanPhaseShiftA + 11*ScanPhaseShiftB)
  1:253: ScanMag1*1 ScanPhase1 + (6*ScanPhaseShiftA + 12*ScanPhaseShiftB)
  1:254: ScanMag1*1 ScanPhase1 + (6*ScanPhaseShiftA + 13*ScanPhaseShiftB)
  1:255: ScanMag1*1 ScanPhase1 + (6*ScanPhaseShiftA + 14*ScanPhaseShiftB)
  1:256: ScanMag1*1 ScanPhase1 + (6*ScanPhaseShiftA + 15*ScanPhaseShiftB)
  1:257: ScanMag1*1 ScanPhase1 + (6*ScanPhaseShiftA + 16*ScanPhaseShiftB)
  1:258: ScanMag1*1 ScanPhase1 + (6*ScanPhaseShiftA + 17*ScanPhaseShiftB)
  1:259: ScanMag1*1 ScanPhase1 + (6*ScanPhaseShiftA + 18*ScanPhaseShiftB)
  1:260: ScanMag1*1 ScanPhase1 + (6*ScanPhaseShiftA + 19*ScanPhaseShiftB)
  1:261: ScanMag1*1 ScanPhase1 + (6*ScanPhaseShiftA + 20*ScanPhaseShiftB)
  1:262: ScanMag1*1 ScanPhase1 + (6*ScanPhaseShiftA + 21*ScanPhaseShiftB)
  1:263: ScanMag1*1 ScanPhase1 + (6*ScanPhaseShiftA + 22*ScanPhaseShiftB)
  1:264: ScanMag1*1 ScanPhase1 + (6*ScanPhaseShiftA + 23*ScanPhaseShiftB)
  1:265: ScanMag1*1 ScanPhase1 + (6*ScanPhaseShiftA + 24*ScanPhaseShiftB)
  1:266: ScanMag1*1 ScanPhase1 + (6*ScanPhaseShiftA + 25*ScanPhaseShiftB)
  1:267: ScanMag1*1 ScanPhase1 + (6*ScanPhaseShiftA + 26*ScanPhaseShiftB)
  1:268: ScanMag1*1 ScanPhase1 + (6*ScanPhaseShiftA + 27*ScanPhaseShiftB)
  1:269: ScanMag1*1 ScanPhase1 + (6*ScanPhaseShiftA + 28*ScanPhaseShiftB)
  1:270: ScanMag1*1 ScanPhase1 + (6*ScanPhaseShiftA + 29*ScanPhaseShiftB)
  1:271: ScanMag1*1 ScanPhase1 + (6*ScanPhaseShiftA + 30*ScanPhaseShiftB)
  1:272: ScanMag1*1 ScanPhase1 + (6*ScanPhaseShiftA + 31*ScanPhaseShiftB)
  1:273: ScanMag1*1 ScanPhase1 + (6*ScanPhaseShiftA + 32*ScanPhaseShiftB)
  1:274: ScanMag1*1 ScanPhase1 + (6*ScanPhaseShiftA + 33*ScanPhaseShiftB)
  1:275: ScanMag1*1 ScanPhase1 + (6*ScanPhaseShiftA + 34*ScanPhaseShiftB)
  1:276: ScanMag1*1 ScanPhase1 + (6*ScanPhaseShiftA + 35*ScanPhaseShiftB)
  1:277: ScanMag1*1 ScanPhase1 + (6*ScanPhaseShiftA + 36*ScanPhaseShiftB)
  1:278: ScanMag1*1 ScanPhase1 + (6*ScanPhaseShiftA + 37*ScanPhaseShiftB)
  1:279: ScanMag1*1 ScanPhase1 + (6*ScanPhaseShiftA + 38*ScanPhaseShiftB)
  1:280: ScanMag1*1 ScanPhase1 + (6*ScanPhaseShiftA + 39*ScanPhaseShiftB)
  1:281: ScanMag1*1 ScanPhase1 + (7*ScanPhaseShiftA + 0*ScanPhaseShiftB)
  1:282: ScanMag1*1 ScanPhase1 + (7*ScanPhaseShiftA + 1*ScanPhaseShiftB)
  1:283: ScanMag1*1 ScanPhase1 + (7*ScanPhaseShiftA + 2*ScanPhaseShiftB)
  1:284: ScanMag1*1 ScanPhase1 + (7*ScanPhaseShiftA + 3*ScanPhaseShiftB)
  1:285: ScanMag1*1 ScanPhase1 + (7*ScanPhaseShiftA + 4*ScanPhaseShiftB)
  1:286: ScanMag1*1 ScanPhase1 + (7*ScanPhaseShiftA + 5*ScanPhaseShiftB)
  1:287: ScanMag1*1 ScanPhase1 + (7*ScanPhaseShiftA + 6*ScanPhaseShiftB)
  1:288: ScanMag1*1 ScanPhase1 + (7*ScanPhaseShiftA + 7*ScanPhaseShiftB)
  1:289: ScanMag1*1 ScanPhase1 + (7*ScanPhaseShiftA + 8*ScanPhaseShiftB)
  1:290: ScanMag1*1 ScanPhase1 + (7*ScanPhaseShiftA + 9*ScanPhaseShiftB)
  1:291: ScanMag1*1 ScanPhase1 + (7*ScanPhaseShiftA + 10*ScanPhaseShiftB)
  1:292: ScanMag1*1 ScanPhase1 + (7*ScanPhaseShiftA + 11*ScanPhaseShiftB)
  1:293: ScanMag1*1 ScanPhase1 + (7*ScanPhaseShiftA + 12*ScanPhaseShiftB)
  1:294: ScanMag1*1 ScanPhase1 + (7*ScanPhaseShiftA + 13*ScanPhaseShiftB)
  1:295: ScanMag1*1 ScanPhase1 + (7*ScanPhaseShiftA + 14*ScanPhaseShiftB)
  1:296: ScanMag1*1 ScanPhase1 + (7*ScanPhaseShiftA + 15*ScanPhaseShiftB)
  1:297: ScanMag1*1 ScanPhase1 + (7*ScanPhaseShiftA + 16*ScanPhaseShiftB)
  1:298: ScanMag1*1 ScanPhase1 + (7*ScanPhaseShiftA + 17*ScanPhaseShiftB)
  1:299: ScanMag1*1 ScanPhase1 + (7*ScanPhaseShiftA + 18*ScanPhaseShiftB)
  1:300: ScanMag1*1 ScanPhase1 + (7*ScanPhaseShiftA + 19*ScanPhaseShiftB)
  1:301: ScanMag1*1 ScanPhase1 + (7*ScanPhaseShiftA + 20*ScanPhaseShiftB)
  1:302: ScanMag1*1 ScanPhase1 + (7*ScanPhaseShiftA + 21*ScanPhaseShiftB)
  1:303: ScanMag1*1 ScanPhase1 + (7*ScanPhaseShiftA + 22*ScanPhaseShiftB)
  1:304: ScanMag1*1 ScanPhase1 + (7*ScanPhaseShiftA + 23*ScanPhaseShiftB)
  1:305: ScanMag1*1 ScanPhase1 + (7*ScanPhaseShiftA + 24*ScanPhaseShiftB)
  1:306: ScanMag1*1 ScanPhase1 + (7*ScanPhaseShiftA + 25*ScanPhaseShiftB)
  1:307: ScanMag1*1 ScanPhase1 + (7*ScanPhaseShiftA + 26*ScanPhaseShiftB)
  1:308: ScanMag1*1 ScanPhase1 + (7*ScanPhaseShiftA + 27*ScanPhaseShiftB)
  1:309: ScanMag1*1 ScanPhase1 + (7*ScanPhaseShiftA + 28*ScanPhaseShiftB)
  1:310: ScanMag1*1 ScanPhase1 + (7*ScanPhaseShiftA + 29*ScanPhaseShiftB)
  1:311: ScanMag1*1 ScanPhase1 + (7*ScanPhaseShiftA + 30*ScanPhaseShiftB)
  1:312: ScanMag1*1 ScanPhase1 + (7*ScanPhaseShiftA + 31*ScanPhaseShiftB)
  1:313: ScanMag1*1 ScanPhase1 + (7*ScanPhaseShiftA + 32*ScanPhaseShiftB)
  1:314: ScanMag1*1 ScanPhase1 + (7*ScanPhaseShiftA + 33*ScanPhaseShiftB)
  1:315: ScanMag1*1 ScanPhase1 + (7*ScanPhaseShiftA + 34*ScanPhaseShiftB)
  1:316: ScanMag1*1 ScanPhase1 + (7*ScanPhaseShiftA + 35*ScanPhaseShiftB)
  1:317: ScanMag1*1 ScanPhase1 + (7*ScanPhaseShiftA + 36*ScanPhaseShiftB)
  1:318: ScanMag1*1 ScanPhase1 + (7*ScanPhaseShiftA + 37*ScanPhaseShiftB)
  1:319: ScanMag1*1 ScanPhase1 + (7*ScanPhaseShiftA + 38*ScanPhaseShiftB)
  1:320: ScanMag1*1 ScanPhase1 + (7*ScanPhaseShiftA + 39*ScanPhaseShiftB)
  1:321: ScanMag1*1 ScanPhase1 + (8*ScanPhaseShiftA + 0*ScanPhaseShiftB)
  1:322: ScanMag1*1 ScanPhase1 + (8*ScanPhaseShiftA + 1*ScanPhaseShiftB)
  1:323: ScanMag1*1 ScanPhase1 + (8*ScanPhaseShiftA + 2*ScanPhaseShiftB)
  1:324: ScanMag1*1 ScanPhase1 + (8*ScanPhaseShiftA + 3*ScanPhaseShiftB)
  1:325: ScanMag1*1 ScanPhase1 + (8*ScanPhaseShiftA + 4*ScanPhaseShiftB)
  1:326: ScanMag1*1 ScanPhase1 + (8*ScanPhaseShiftA + 5*ScanPhaseShiftB)
  1:327: ScanMag1*1 ScanPhase1 + (8*ScanPhaseShiftA + 6*ScanPhaseShiftB)
  1:328: ScanMag1*1 ScanPhase1 + (8*ScanPhaseShiftA + 7*ScanPhaseShiftB)
  1:329: ScanMag1*1 ScanPhase1 + (8*ScanPhaseShiftA + 8*ScanPhaseShiftB)
  1:330: ScanMag1*1 ScanPhase1 + (8*ScanPhaseShiftA + 9*ScanPhaseShiftB)
  1:331: ScanMag1*1 ScanPhase1 + (8*ScanPhaseShiftA + 10*ScanPhaseShiftB)
  1:332: ScanMag1*1 ScanPhase1 + (8*ScanPhaseShiftA + 11*ScanPhaseShiftB)
  1:333: ScanMag1*1 ScanPhase1 + (8*ScanPhaseShiftA + 12*ScanPhaseShiftB)
  1:334: ScanMag1*1 ScanPhase1 + (8*ScanPhaseShiftA + 13*ScanPhaseShiftB)
  1:335: ScanMag1*1 ScanPhase1 + (8*ScanPhaseShiftA + 14*ScanPhaseShiftB)
  1:336: ScanMag1*1 ScanPhase1 + (8*ScanPhaseShiftA + 15*ScanPhaseShiftB)
  1:337: ScanMag1*1 ScanPhase1 + (8*ScanPhaseShiftA + 16*ScanPhaseShiftB)
  1:338: ScanMag1*1 ScanPhase1 + (8*ScanPhaseShiftA + 17*ScanPhaseShiftB)
  1:339: ScanMag1*1 ScanPhase1 + (8*ScanPhaseShiftA + 18*ScanPhaseShiftB)
  1:340: ScanMag1*1 ScanPhase1 + (8*ScanPhaseShiftA + 19*ScanPhaseShiftB)
  1:341: ScanMag1*1 ScanPhase1 + (8*ScanPhaseShiftA + 20*ScanPhaseShiftB)
  1:342: ScanMag1*1 ScanPhase1 + (8*ScanPhaseShiftA + 21*ScanPhaseShiftB)
  1:343: ScanMag1*1 ScanPhase1 + (8*ScanPhaseShiftA + 22*ScanPhaseShiftB)
  1:344: ScanMag1*1 ScanPhase1 + (8*ScanPhaseShiftA + 23*ScanPhaseShiftB)
  1:345: ScanMag1*1 ScanPhase1 + (8*ScanPhaseShiftA + 24*ScanPhaseShiftB)
  1:346: ScanMag1*1 ScanPhase1 + (8*ScanPhaseShiftA + 25*ScanPhaseShiftB)
  1:347: ScanMag1*1 ScanPhase1 + (8*ScanPhaseShiftA + 26*ScanPhaseShiftB)
  1:348: ScanMag1*1 ScanPhase1 + (8*ScanPhaseShiftA + 27*ScanPhaseShiftB)
  1:349: ScanMag1*1 ScanPhase1 + (8*ScanPhaseShiftA + 28*ScanPhaseShiftB)
  1:350: ScanMag1*1 ScanPhase1 + (8*ScanPhaseShiftA + 29*ScanPhaseShiftB)
  1:351: ScanMag1*1 ScanPhase1 + (8*ScanPhaseShiftA + 30*ScanPhaseShiftB)
  1:352: ScanMag1*1 ScanPhase1 + (8*ScanPhaseShiftA + 31*ScanPhaseShiftB)
  1:353: ScanMag1*1 ScanPhase1 + (8*ScanPhaseShiftA + 32*ScanPhaseShiftB)
  1:354: ScanMag1*1 ScanPhase1 + (8*ScanPhaseShiftA + 33*ScanPhaseShiftB)
  1:355: ScanMag1*1 ScanPhase1 + (8*ScanPhaseShiftA + 34*ScanPhaseShiftB)
  1:356: ScanMag1*1 ScanPhase1 + (8*ScanPhaseShiftA + 35*ScanPhaseShiftB)
  1:357: ScanMag1*1 ScanPhase1 + (8*ScanPhaseShiftA + 36*ScanPhaseShiftB)
  1:358: ScanMag1*1 ScanPhase1 + (8*ScanPhaseShiftA + 37*ScanPhaseShiftB)
  1:359: ScanMag1*1 ScanPhase1 + (8*ScanPhaseShiftA + 38*ScanPhaseShiftB)
  1:360: ScanMag1*1 ScanPhase1 + (8*ScanPhaseShiftA + 39*ScanPhaseShiftB)
  1:361: ScanMag1*1 ScanPhase1 + (9*ScanPhaseShiftA + 0*ScanPhaseShiftB)
  1:362: ScanMag1*1 ScanPhase1 + (9*ScanPhaseShiftA + 1*ScanPhaseShiftB)
  1:363: ScanMag1*1 ScanPhase1 + (9*ScanPhaseShiftA + 2*ScanPhaseShiftB)
  1:364: ScanMag1*1 ScanPhase1 + (9*ScanPhaseShiftA + 3*ScanPhaseShiftB)
  1:365: ScanMag1*1 ScanPhase1 + (9*ScanPhaseShiftA + 4*ScanPhaseShiftB)
  1:366: ScanMag1*1 ScanPhase1 + (9*ScanPhaseShiftA + 5*ScanPhaseShiftB)
  1:367: ScanMag1*1 ScanPhase1 + (9*ScanPhaseShiftA + 6*ScanPhaseShiftB)
  1:368: ScanMag1*1 ScanPhase1 + (9*ScanPhaseShiftA + 7*ScanPhaseShiftB)
  1:369: ScanMag1*1 ScanPhase1 + (9*ScanPhaseShiftA + 8*ScanPhaseShiftB)
  1:370: ScanMag1*1 ScanPhase1 + (9*ScanPhaseShiftA + 9*ScanPhaseShiftB)
  1:371: ScanMag1*1 ScanPhase1 + (9*ScanPhaseShiftA + 10*ScanPhaseShiftB)
  1:372: ScanMag1*1 ScanPhase1 + (9*ScanPhaseShiftA + 11*ScanPhaseShiftB)
  1:373: ScanMag1*1 ScanPhase1 + (9*ScanPhaseShiftA + 12*ScanPhaseShiftB)
  1:374: ScanMag1*1 ScanPhase1 + (9*ScanPhaseShiftA + 13*ScanPhaseShiftB)
  1:375: ScanMag1*1 ScanPhase1 + (9*ScanPhaseShiftA + 14*ScanPhaseShiftB)
  1:376: ScanMag1*1 ScanPhase1 + (9*ScanPhaseShiftA + 15*ScanPhaseShiftB)
  1:377: ScanMag1*1 ScanPhase1 + (9*ScanPhaseShiftA + 16*ScanPhaseShiftB)
  1:378: ScanMag1*1 ScanPhase1 + (9*ScanPhaseShiftA + 17*ScanPhaseShiftB)
  1:379: ScanMag1*1 ScanPhase1 + (9*ScanPhaseShiftA + 18*ScanPhaseShiftB)
  1:380: ScanMag1*1 ScanPhase1 + (9*ScanPhaseShiftA + 19*ScanPhaseShiftB)
  1:381: ScanMag1*1 ScanPhase1 + (9*ScanPhaseShiftA + 20*ScanPhaseShiftB)
  1:382: ScanMag1*1 ScanPhase1 + (9*ScanPhaseShiftA + 21*ScanPhaseShiftB)
  1:383: ScanMag1*1 ScanPhase1 + (9*ScanPhaseShiftA + 22*ScanPhaseShiftB)
  1:384: ScanMag1*1 ScanPhase1 + (9*ScanPhaseShiftA + 23*ScanPhaseShiftB)
  1:385: ScanMag1*1 ScanPhase1 + (9*ScanPhaseShiftA + 24*ScanPhaseShiftB)
  1:386: ScanMag1*1 ScanPhase1 + (9*ScanPhaseShiftA + 25*ScanPhaseShiftB)
  1:387: ScanMag1*1 ScanPhase1 + (9*ScanPhaseShiftA + 26*ScanPhaseShiftB)
  1:388: ScanMag1*1 ScanPhase1 + (9*ScanPhaseShiftA + 27*ScanPhaseShiftB)
  1:389: ScanMag1*1 ScanPhase1 + (9*ScanPhaseShiftA + 28*ScanPhaseShiftB)
  1:390: ScanMag1*1 ScanPhase1 + (9*ScanPhaseShiftA + 29*ScanPhaseShiftB)
  1:391: ScanMag1*1 ScanPhase1 + (9*ScanPhaseShiftA + 30*ScanPhaseShiftB)
  1:392: ScanMag1*1 ScanPhase1 + (9*ScanPhaseShiftA + 31*ScanPhaseShiftB)
  1:393: ScanMag1*1 ScanPhase1 + (9*ScanPhaseShiftA + 32*ScanPhaseShiftB)
  1:394: ScanMag1*1 ScanPhase1 + (9*ScanPhaseShiftA + 33*ScanPhaseShiftB)
  1:395: ScanMag1*1 ScanPhase1 + (9*ScanPhaseShiftA + 34*ScanPhaseShiftB)
  1:396: ScanMag1*1 ScanPhase1 + (9*ScanPhaseShiftA + 35*ScanPhaseShiftB)
  1:397: ScanMag1*1 ScanPhase1 + (9*ScanPhaseShiftA + 36*ScanPhaseShiftB)
  1:398: ScanMag1*1 ScanPhase1 + (9*ScanPhaseShiftA + 37*ScanPhaseShiftB)
  1:399: ScanMag1*1 ScanPhase1 + (9*ScanPhaseShiftA + 38*ScanPhaseShiftB)
  1:400: ScanMag1*1 ScanPhase1 + (9*ScanPhaseShiftA + 39*ScanPhaseShiftB)
  1:401: ScanMag1*1 ScanPhase1 + (10*ScanPhaseShiftA + 0*ScanPhaseShiftB)
  1:402: ScanMag1*1 ScanPhase1 + (10*ScanPhaseShiftA + 1*ScanPhaseShiftB)
  1:403: ScanMag1*1 ScanPhase1 + (10*ScanPhaseShiftA + 2*ScanPhaseShiftB)
  1:404: ScanMag1*1 ScanPhase1 + (10*ScanPhaseShiftA + 3*ScanPhaseShiftB)
  1:405: ScanMag1*1 ScanPhase1 + (10*ScanPhaseShiftA + 4*ScanPhaseShiftB)
  1:406: ScanMag1*1 ScanPhase1 + (10*ScanPhaseShiftA + 5*ScanPhaseShiftB)
  1:407: ScanMag1*1 ScanPhase1 + (10*ScanPhaseShiftA + 6*ScanPhaseShiftB)
  1:408: ScanMag1*1 ScanPhase1 + (10*ScanPhaseShiftA + 7*ScanPhaseShiftB)
  1:409: ScanMag1*1 ScanPhase1 + (10*ScanPhaseShiftA + 8*ScanPhaseShiftB)
  1:410: ScanMag1*1 ScanPhase1 + (10*ScanPhaseShiftA + 9*ScanPhaseShiftB)
  1:411: ScanMag1*1 ScanPhase1 + (10*ScanPhaseShiftA + 10*ScanPhaseShiftB)
  1:412: ScanMag1*1 ScanPhase1 + (10*ScanPhaseShiftA + 11*ScanPhaseShiftB)
  1:413: ScanMag1*1 ScanPhase1 + (10*ScanPhaseShiftA + 12*ScanPhaseShiftB)
  1:414: ScanMag1*1 ScanPhase1 + (10*ScanPhaseShiftA + 13*ScanPhaseShiftB)
  1:415: ScanMag1*1 ScanPhase1 + (10*ScanPhaseShiftA + 14*ScanPhaseShiftB)
  1:416: ScanMag1*1 ScanPhase1 + (10*ScanPhaseShiftA + 15*ScanPhaseShiftB)
  1:417: ScanMag1*1 ScanPhase1 + (10*ScanPhaseShiftA + 16*ScanPhaseShiftB)
  1:418: ScanMag1*1 ScanPhase1 + (10*ScanPhaseShiftA + 17*ScanPhaseShiftB)
  1:419: ScanMag1*1 ScanPhase1 + (10*ScanPhaseShiftA + 18*ScanPhaseShiftB)
  1:420: ScanMag1*1 ScanPhase1 + (10*ScanPhaseShiftA + 19*ScanPhaseShiftB)
  1:421: ScanMag1*1 ScanPhase1 + (10*ScanPhaseShiftA + 20*ScanPhaseShiftB)
  1:422: ScanMag1*1 ScanPhase1 + (10*ScanPhaseShiftA + 21*ScanPhaseShiftB)
  1:423: ScanMag1*1 ScanPhase1 + (10*ScanPhaseShiftA + 22*ScanPhaseShiftB)
  1:424: ScanMag1*1 ScanPhase1 + (10*ScanPhaseShiftA + 23*ScanPhaseShiftB)
  1:425: ScanMag1*1 ScanPhase1 + (10*ScanPhaseShiftA + 24*ScanPhaseShiftB)
  1:426: ScanMag1*1 ScanPhase1 + (10*ScanPhaseShiftA + 25*ScanPhaseShiftB)
  1:427: ScanMag1*1 ScanPhase1 + (10*ScanPhaseShiftA + 26*ScanPhaseShiftB)
  1:428: ScanMag1*1 ScanPhase1 + (10*ScanPhaseShiftA + 27*ScanPhaseShiftB)
  1:429: ScanMag1*1 ScanPhase1 + (10*ScanPhaseShiftA + 28*ScanPhaseShiftB)
  1:430: ScanMag1*1 ScanPhase1 + (10*ScanPhaseShiftA + 29*ScanPhaseShiftB)
  1:431: ScanMag1*1 ScanPhase1 + (10*ScanPhaseShiftA + 30*ScanPhaseShiftB)
  1:432: ScanMag1*1 ScanPhase1 + (10*ScanPhaseShiftA + 31*ScanPhaseShiftB)
  1:433: ScanMag1*1 ScanPhase1 + (10*ScanPhaseShiftA + 32*ScanPhaseShiftB)
  1:434: ScanMag1*1 ScanPhase1 + (10*ScanPhaseShiftA + 33*ScanPhaseShiftB)
  1:435: ScanMag1*1 ScanPhase1 + (10*ScanPhaseShiftA + 34*ScanPhaseShiftB)
  1:436: ScanMag1*1 ScanPhase1 + (10*ScanPhaseShiftA + 35*ScanPhaseShiftB)
  1:437: ScanMag1*1 ScanPhase1 + (10*ScanPhaseShiftA + 36*ScanPhaseShiftB)
  1:438: ScanMag1*1 ScanPhase1 + (10*ScanPhaseShiftA + 37*ScanPhaseShiftB)
  1:439: ScanMag1*1 ScanPhase1 + (10*ScanPhaseShiftA + 38*ScanPhaseShiftB)
  1:440: ScanMag1*1 ScanPhase1 + (10*ScanPhaseShiftA + 39*ScanPhaseShiftB)
  1:441: ScanMag1*1 ScanPhase1 + (11*ScanPhaseShiftA + 0*ScanPhaseShiftB)
  1:442: ScanMag1*1 ScanPhase1 + (11*ScanPhaseShiftA + 1*ScanPhaseShiftB)
  1:443: ScanMag1*1 ScanPhase1 + (11*ScanPhaseShiftA + 2*ScanPhaseShiftB)
  1:444: ScanMag1*1 ScanPhase1 + (11*ScanPhaseShiftA + 3*ScanPhaseShiftB)
  1:445: ScanMag1*1 ScanPhase1 + (11*ScanPhaseShiftA + 4*ScanPhaseShiftB)
  1:446: ScanMag1*1 ScanPhase1 + (11*ScanPhaseShiftA + 5*ScanPhaseShiftB)
  1:447: ScanMag1*1 ScanPhase1 + (11*ScanPhaseShiftA + 6*ScanPhaseShiftB)
  1:448: ScanMag1*1 ScanPhase1 + (11*ScanPhaseShiftA + 7*ScanPhaseShiftB)
  1:449: ScanMag1*1 ScanPhase1 + (11*ScanPhaseShiftA + 8*ScanPhaseShiftB)
  1:450: ScanMag1*1 ScanPhase1 + (11*ScanPhaseShiftA + 9*ScanPhaseShiftB)
  1:451: ScanMag1*1 ScanPhase1 + (11*ScanPhaseShiftA + 10*ScanPhaseShiftB)
  1:452: ScanMag1*1 ScanPhase1 + (11*ScanPhaseShiftA + 11*ScanPhaseShiftB)
  1:453: ScanMag1*1 ScanPhase1 + (11*ScanPhaseShiftA + 12*ScanPhaseShiftB)
  1:454: ScanMag1*1 ScanPhase1 + (11*ScanPhaseShiftA + 13*ScanPhaseShiftB)
  1:455: ScanMag1*1 ScanPhase1 + (11*ScanPhaseShiftA + 14*ScanPhaseShiftB)
  1:456: ScanMag1*1 ScanPhase1 + (11*ScanPhaseShiftA + 15*ScanPhaseShiftB)
  1:457: ScanMag1*1 ScanPhase1 + (11*ScanPhaseShiftA + 16*ScanPhaseShiftB)
  1:458: ScanMag1*1 ScanPhase1 + (11*ScanPhaseShiftA + 17*ScanPhaseShiftB)
  1:459: ScanMag1*1 ScanPhase1 + (11*ScanPhaseShiftA + 18*ScanPhaseShiftB)
  1:460: ScanMag1*1 ScanPhase1 + (11*ScanPhaseShiftA + 19*ScanPhaseShiftB)
  1:461: ScanMag1*1 ScanPhase1 + (11*ScanPhaseShiftA + 20*ScanPhaseShiftB)
  1:462: ScanMag1*1 ScanPhase1 + (11*ScanPhaseShiftA + 21*ScanPhaseShiftB)
  1:463: ScanMag1*1 ScanPhase1 + (11*ScanPhaseShiftA + 22*ScanPhaseShiftB)
  1:464: ScanMag1*1 ScanPhase1 + (11*ScanPhaseShiftA + 23*ScanPhaseShiftB)
  1:465: ScanMag1*1 ScanPhase1 + (11*ScanPhaseShiftA + 24*ScanPhaseShiftB)
  1:466: ScanMag1*1 ScanPhase1 + (11*ScanPhaseShiftA + 25*ScanPhaseShiftB)
  1:467: ScanMag1*1 ScanPhase1 + (11*ScanPhaseShiftA + 26*ScanPhaseShiftB)
  1:468: ScanMag1*1 ScanPhase1 + (11*ScanPhaseShiftA + 27*ScanPhaseShiftB)
  1:469: ScanMag1*1 ScanPhase1 + (11*ScanPhaseShiftA + 28*ScanPhaseShiftB)
  1:470: ScanMag1*1 ScanPhase1 + (11*ScanPhaseShiftA + 29*ScanPhaseShiftB)
  1:471: ScanMag1*1 ScanPhase1 + (11*ScanPhaseShiftA + 30*ScanPhaseShiftB)
  1:472: ScanMag1*1 ScanPhase1 + (11*ScanPhaseShiftA + 31*ScanPhaseShiftB)
  1:473: ScanMag1*1 ScanPhase1 + (11*ScanPhaseShiftA + 32*ScanPhaseShiftB)
  1:474: ScanMag1*1 ScanPhase1 + (11*ScanPhaseShiftA + 33*ScanPhaseShiftB)
  1:475: ScanMag1*1 ScanPhase1 + (11*ScanPhaseShiftA + 34*ScanPhaseShiftB)
  1:476: ScanMag1*1 ScanPhase1 + (11*ScanPhaseShiftA + 35*ScanPhaseShiftB)
  1:477: ScanMag1*1 ScanPhase1 + (11*ScanPhaseShiftA + 36*ScanPhaseShiftB)
  1:478: ScanMag1*1 ScanPhase1 + (11*ScanPhaseShiftA + 37*ScanPhaseShiftB)
  1:479: ScanMag1*1 ScanPhase1 + (11*ScanPhaseShiftA + 38*ScanPhaseShiftB)
  1:480: ScanMag1*1 ScanPhase1 + (11*ScanPhaseShiftA + 39*ScanPhaseShiftB)
  1:481: ScanMag1*1 ScanPhase1 + (12*ScanPhaseShiftA + 0*ScanPhaseShiftB)
  1:482: ScanMag1*1 ScanPhase1 + (12*ScanPhaseShiftA + 1*ScanPhaseShiftB)
  1:483: ScanMag1*1 ScanPhase1 + (12*ScanPhaseShiftA + 2*ScanPhaseShiftB)
  1:484: ScanMag1*1 ScanPhase1 + (12*ScanPhaseShiftA + 3*ScanPhaseShiftB)
  1:485: ScanMag1*1 ScanPhase1 + (12*ScanPhaseShiftA + 4*ScanPhaseShiftB)
  1:486: ScanMag1*1 ScanPhase1 + (12*ScanPhaseShiftA + 5*ScanPhaseShiftB)
  1:487: ScanMag1*1 ScanPhase1 + (12*ScanPhaseShiftA + 6*ScanPhaseShiftB)
  1:488: ScanMag1*1 ScanPhase1 + (12*ScanPhaseShiftA + 7*ScanPhaseShiftB)
  1:489: ScanMag1*1 ScanPhase1 + (12*ScanPhaseShiftA + 8*ScanPhaseShiftB)
  1:490: ScanMag1*1 ScanPhase1 + (12*ScanPhaseShiftA + 9*ScanPhaseShiftB)
  1:491: ScanMag1*1 ScanPhase1 + (12*ScanPhaseShiftA + 10*ScanPhaseShiftB)
  1:492: ScanMag1*1 ScanPhase1 + (12*ScanPhaseShiftA + 11*ScanPhaseShiftB)
  1:493: ScanMag1*1 ScanPhase1 + (12*ScanPhaseShiftA + 12*ScanPhaseShiftB)
  1:494: ScanMag1*1 ScanPhase1 + (12*ScanPhaseShiftA + 13*ScanPhaseShiftB)
  1:495: ScanMag1*1 ScanPhase1 + (12*ScanPhaseShiftA + 14*ScanPhaseShiftB)
  1:496: ScanMag1*1 ScanPhase1 + (12*ScanPhaseShiftA + 15*ScanPhaseShiftB)
  1:497: ScanMag1*1 ScanPhase1 + (12*ScanPhaseShiftA + 16*ScanPhaseShiftB)
  1:498: ScanMag1*1 ScanPhase1 + (12*ScanPhaseShiftA + 17*ScanPhaseShiftB)
  1:499: ScanMag1*1 ScanPhase1 + (12*ScanPhaseShiftA + 18*ScanPhaseShiftB)
  1:500: ScanMag1*1 ScanPhase1 + (12*ScanPhaseShiftA + 19*ScanPhaseShiftB)
  1:501: ScanMag1*1 ScanPhase1 + (12*ScanPhaseShiftA + 20*ScanPhaseShiftB)
  1:502: ScanMag1*1 ScanPhase1 + (12*ScanPhaseShiftA + 21*ScanPhaseShiftB)
  1:503: ScanMag1*1 ScanPhase1 + (12*ScanPhaseShiftA + 22*ScanPhaseShiftB)
  1:504: ScanMag1*1 ScanPhase1 + (12*ScanPhaseShiftA + 23*ScanPhaseShiftB)
  1:505: ScanMag1*1 ScanPhase1 + (12*ScanPhaseShiftA + 24*ScanPhaseShiftB)
  1:506: ScanMag1*1 ScanPhase1 + (12*ScanPhaseShiftA + 25*ScanPhaseShiftB)
  1:507: ScanMag1*1 ScanPhase1 + (12*ScanPhaseShiftA + 26*ScanPhaseShiftB)
  1:508: ScanMag1*1 ScanPhase1 + (12*ScanPhaseShiftA + 27*ScanPhaseShiftB)
  1:509: ScanMag1*1 ScanPhase1 + (12*ScanPhaseShiftA + 28*ScanPhaseShiftB)
  1:510: ScanMag1*1 ScanPhase1 + (12*ScanPhaseShiftA + 29*ScanPhaseShiftB)
  1:511: ScanMag1*1 ScanPhase1 + (12*ScanPhaseShiftA + 30*ScanPhaseShiftB)
  1:512: ScanMag1*1 ScanPhase1 + (12*ScanPhaseShiftA + 31*ScanPhaseShiftB)
  1:513: ScanMag1*1 ScanPhase1 + (12*ScanPhaseShiftA + 32*ScanPhaseShiftB)
  1:514: ScanMag1*1 ScanPhase1 + (12*ScanPhaseShiftA + 33*ScanPhaseShiftB)
  1:515: ScanMag1*1 ScanPhase1 + (12*ScanPhaseShiftA + 34*ScanPhaseShiftB)
  1:516: ScanMag1*1 ScanPhase1 + (12*ScanPhaseShiftA + 35*ScanPhaseShiftB)
  1:517: ScanMag1*1 ScanPhase1 + (12*ScanPhaseShiftA + 36*ScanPhaseShiftB)
  1:518: ScanMag1*1 ScanPhase1 + (12*ScanPhaseShiftA + 37*ScanPhaseShiftB)
  1:519: ScanMag1*1 ScanPhase1 + (12*ScanPhaseShiftA + 38*ScanPhaseShiftB)
  1:520: ScanMag1*1 ScanPhase1 + (12*ScanPhaseShiftA + 39*ScanPhaseShiftB)
  1:521: ScanMag1*1 ScanPhase1 + (13*ScanPhaseShiftA + 0*ScanPhaseShiftB)
  1:522: ScanMag1*1 ScanPhase1 + (13*ScanPhaseShiftA + 1*ScanPhaseShiftB)
  1:523: ScanMag1*1 ScanPhase1 + (13*ScanPhaseShiftA + 2*ScanPhaseShiftB)
  1:524: ScanMag1*1 ScanPhase1 + (13*ScanPhaseShiftA + 3*ScanPhaseShiftB)
  1:525: ScanMag1*1 ScanPhase1 + (13*ScanPhaseShiftA + 4*ScanPhaseShiftB)
  1:526: ScanMag1*1 ScanPhase1 + (13*ScanPhaseShiftA + 5*ScanPhaseShiftB)
  1:527: ScanMag1*1 ScanPhase1 + (13*ScanPhaseShiftA + 6*ScanPhaseShiftB)
  1:528: ScanMag1*1 ScanPhase1 + (13*ScanPhaseShiftA + 7*ScanPhaseShiftB)
  1:529: ScanMag1*1 ScanPhase1 + (13*ScanPhaseShiftA + 8*ScanPhaseShiftB)
  1:530: ScanMag1*1 ScanPhase1 + (13*ScanPhaseShiftA + 9*ScanPhaseShiftB)
  1:531: ScanMag1*1 ScanPhase1 + (13*ScanPhaseShiftA + 10*ScanPhaseShiftB)
  1:532: ScanMag1*1 ScanPhase1 + (13*ScanPhaseShiftA + 11*ScanPhaseShiftB)
  1:533: ScanMag1*1 ScanPhase1 + (13*ScanPhaseShiftA + 12*ScanPhaseShiftB)
  1:534: ScanMag1*1 ScanPhase1 + (13*ScanPhaseShiftA + 13*ScanPhaseShiftB)
  1:535: ScanMag1*1 ScanPhase1 + (13*ScanPhaseShiftA + 14*ScanPhaseShiftB)
  1:536: ScanMag1*1 ScanPhase1 + (13*ScanPhaseShiftA + 15*ScanPhaseShiftB)
  1:537: ScanMag1*1 ScanPhase1 + (13*ScanPhaseShiftA + 16*ScanPhaseShiftB)
  1:538: ScanMag1*1 ScanPhase1 + (13*ScanPhaseShiftA + 17*ScanPhaseShiftB)
  1:539: ScanMag1*1 ScanPhase1 + (13*ScanPhaseShiftA + 18*ScanPhaseShiftB)
  1:540: ScanMag1*1 ScanPhase1 + (13*ScanPhaseShiftA + 19*ScanPhaseShiftB)
  1:541: ScanMag1*1 ScanPhase1 + (13*ScanPhaseShiftA + 20*ScanPhaseShiftB)
  1:542: ScanMag1*1 ScanPhase1 + (13*ScanPhaseShiftA + 21*ScanPhaseShiftB)
  1:543: ScanMag1*1 ScanPhase1 + (13*ScanPhaseShiftA + 22*ScanPhaseShiftB)
  1:544: ScanMag1*1 ScanPhase1 + (13*ScanPhaseShiftA + 23*ScanPhaseShiftB)
  1:545: ScanMag1*1 ScanPhase1 + (13*ScanPhaseShiftA + 24*ScanPhaseShiftB)
  1:546: ScanMag1*1 ScanPhase1 + (13*ScanPhaseShiftA + 25*ScanPhaseShiftB)
  1:547: ScanMag1*1 ScanPhase1 + (13*ScanPhaseShiftA + 26*ScanPhaseShiftB)
  1:548: ScanMag1*1 ScanPhase1 + (13*ScanPhaseShiftA + 27*ScanPhaseShiftB)
  1:549: ScanMag1*1 ScanPhase1 + (13*ScanPhaseShiftA + 28*ScanPhaseShiftB)
  1:550: ScanMag1*1 ScanPhase1 + (13*ScanPhaseShiftA + 29*ScanPhaseShiftB)
  1:551: ScanMag1*1 ScanPhase1 + (13*ScanPhaseShiftA + 30*ScanPhaseShiftB)
  1:552: ScanMag1*1 ScanPhase1 + (13*ScanPhaseShiftA + 31*ScanPhaseShiftB)
  1:553: ScanMag1*1 ScanPhase1 + (13*ScanPhaseShiftA + 32*ScanPhaseShiftB)
  1:554: ScanMag1*1 ScanPhase1 + (13*ScanPhaseShiftA + 33*ScanPhaseShiftB)
  1:555: ScanMag1*1 ScanPhase1 + (13*ScanPhaseShiftA + 34*ScanPhaseShiftB)
  1:556: ScanMag1*1 ScanPhase1 + (13*ScanPhaseShiftA + 35*ScanPhaseShiftB)
  1:557: ScanMag1*1 ScanPhase1 + (13*ScanPhaseShiftA + 36*ScanPhaseShiftB)
  1:558: ScanMag1*1 ScanPhase1 + (13*ScanPhaseShiftA + 37*ScanPhaseShiftB)
  1:559: ScanMag1*1 ScanPhase1 + (13*ScanPhaseShiftA + 38*ScanPhaseShiftB)
  1:560: ScanMag1*1 ScanPhase1 + (13*ScanPhaseShiftA + 39*ScanPhaseShiftB)
  1:561: ScanMag1*1 ScanPhase1 + (14*ScanPhaseShiftA + 0*ScanPhaseShiftB)
  1:562: ScanMag1*1 ScanPhase1 + (14*ScanPhaseShiftA + 1*ScanPhaseShiftB)
  1:563: ScanMag1*1 ScanPhase1 + (14*ScanPhaseShiftA + 2*ScanPhaseShiftB)
  1:564: ScanMag1*1 ScanPhase1 + (14*ScanPhaseShiftA + 3*ScanPhaseShiftB)
  1:565: ScanMag1*1 ScanPhase1 + (14*ScanPhaseShiftA + 4*ScanPhaseShiftB)
  1:566: ScanMag1*1 ScanPhase1 + (14*ScanPhaseShiftA + 5*ScanPhaseShiftB)
  1:567: ScanMag1*1 ScanPhase1 + (14*ScanPhaseShiftA + 6*ScanPhaseShiftB)
  1:568: ScanMag1*1 ScanPhase1 + (14*ScanPhaseShiftA + 7*ScanPhaseShiftB)
  1:569: ScanMag1*1 ScanPhase1 + (14*ScanPhaseShiftA + 8*ScanPhaseShiftB)
  1:570: ScanMag1*1 ScanPhase1 + (14*ScanPhaseShiftA + 9*ScanPhaseShiftB)
  1:571: ScanMag1*1 ScanPhase1 + (14*ScanPhaseShiftA + 10*ScanPhaseShiftB)
  1:572: ScanMag1*1 ScanPhase1 + (14*ScanPhaseShiftA + 11*ScanPhaseShiftB)
  1:573: ScanMag1*1 ScanPhase1 + (14*ScanPhaseShiftA + 12*ScanPhaseShiftB)
  1:574: ScanMag1*1 ScanPhase1 + (14*ScanPhaseShiftA + 13*ScanPhaseShiftB)
  1:575: ScanMag1*1 ScanPhase1 + (14*ScanPhaseShiftA + 14*ScanPhaseShiftB)
  1:576: ScanMag1*1 ScanPhase1 + (14*ScanPhaseShiftA + 15*ScanPhaseShiftB)
  1:577: ScanMag1*1 ScanPhase1 + (14*ScanPhaseShiftA + 16*ScanPhaseShiftB)
  1:578: ScanMag1*1 ScanPhase1 + (14*ScanPhaseShiftA + 17*ScanPhaseShiftB)
  1:579: ScanMag1*1 ScanPhase1 + (14*ScanPhaseShiftA + 18*ScanPhaseShiftB)
  1:580: ScanMag1*1 ScanPhase1 + (14*ScanPhaseShiftA + 19*ScanPhaseShiftB)
  1:581: ScanMag1*1 ScanPhase1 + (14*ScanPhaseShiftA + 20*ScanPhaseShiftB)
  1:582: ScanMag1*1 ScanPhase1 + (14*ScanPhaseShiftA + 21*ScanPhaseShiftB)
  1:583: ScanMag1*1 ScanPhase1 + (14*ScanPhaseShiftA + 22*ScanPhaseShiftB)
  1:584: ScanMag1*1 ScanPhase1 + (14*ScanPhaseShiftA + 23*ScanPhaseShiftB)
  1:585: ScanMag1*1 ScanPhase1 + (14*ScanPhaseShiftA + 24*ScanPhaseShiftB)
  1:586: ScanMag1*1 ScanPhase1 + (14*ScanPhaseShiftA + 25*ScanPhaseShiftB)
  1:587: ScanMag1*1 ScanPhase1 + (14*ScanPhaseShiftA + 26*ScanPhaseShiftB)
  1:588: ScanMag1*1 ScanPhase1 + (14*ScanPhaseShiftA + 27*ScanPhaseShiftB)
  1:589: ScanMag1*1 ScanPhase1 + (14*ScanPhaseShiftA + 28*ScanPhaseShiftB)
  1:590: ScanMag1*1 ScanPhase1 + (14*ScanPhaseShiftA + 29*ScanPhaseShiftB)
  1:591: ScanMag1*1 ScanPhase1 + (14*ScanPhaseShiftA + 30*ScanPhaseShiftB)
  1:592: ScanMag1*1 ScanPhase1 + (14*ScanPhaseShiftA + 31*ScanPhaseShiftB)
  1:593: ScanMag1*1 ScanPhase1 + (14*ScanPhaseShiftA + 32*ScanPhaseShiftB)
  1:594: ScanMag1*1 ScanPhase1 + (14*ScanPhaseShiftA + 33*ScanPhaseShiftB)
  1:595: ScanMag1*1 ScanPhase1 + (14*ScanPhaseShiftA + 34*ScanPhaseShiftB)
  1:596: ScanMag1*1 ScanPhase1 + (14*ScanPhaseShiftA + 35*ScanPhaseShiftB)
  1:597: ScanMag1*1 ScanPhase1 + (14*ScanPhaseShiftA + 36*ScanPhaseShiftB)
  1:598: ScanMag1*1 ScanPhase1 + (14*ScanPhaseShiftA + 37*ScanPhaseShiftB)
  1:599: ScanMag1*1 ScanPhase1 + (14*ScanPhaseShiftA + 38*ScanPhaseShiftB)
  1:600: ScanMag1*1 ScanPhase1 + (14*ScanPhaseShiftA + 39*ScanPhaseShiftB)
  1:601: ScanMag1*1 ScanPhase1 + (15*ScanPhaseShiftA + 0*ScanPhaseShiftB)
  1:602: ScanMag1*1 ScanPhase1 + (15*ScanPhaseShiftA + 1*ScanPhaseShiftB)
  1:603: ScanMag1*1 ScanPhase1 + (15*ScanPhaseShiftA + 2*ScanPhaseShiftB)
  1:604: ScanMag1*1 ScanPhase1 + (15*ScanPhaseShiftA + 3*ScanPhaseShiftB)
  1:605: ScanMag1*1 ScanPhase1 + (15*ScanPhaseShiftA + 4*ScanPhaseShiftB)
  1:606: ScanMag1*1 ScanPhase1 + (15*ScanPhaseShiftA + 5*ScanPhaseShiftB)
  1:607: ScanMag1*1 ScanPhase1 + (15*ScanPhaseShiftA + 6*ScanPhaseShiftB)
  1:608: ScanMag1*1 ScanPhase1 + (15*ScanPhaseShiftA + 7*ScanPhaseShiftB)
  1:609: ScanMag1*1 ScanPhase1 + (15*ScanPhaseShiftA + 8*ScanPhaseShiftB)
  1:610: ScanMag1*1 ScanPhase1 + (15*ScanPhaseShiftA + 9*ScanPhaseShiftB)
  1:611: ScanMag1*1 ScanPhase1 + (15*ScanPhaseShiftA + 10*ScanPhaseShiftB)
  1:612: ScanMag1*1 ScanPhase1 + (15*ScanPhaseShiftA + 11*ScanPhaseShiftB)
  1:613: ScanMag1*1 ScanPhase1 + (15*ScanPhaseShiftA + 12*ScanPhaseShiftB)
  1:614: ScanMag1*1 ScanPhase1 + (15*ScanPhaseShiftA + 13*ScanPhaseShiftB)
  1:615: ScanMag1*1 ScanPhase1 + (15*ScanPhaseShiftA + 14*ScanPhaseShiftB)
  1:616: ScanMag1*1 ScanPhase1 + (15*ScanPhaseShiftA + 15*ScanPhaseShiftB)
  1:617: ScanMag1*1 ScanPhase1 + (15*ScanPhaseShiftA + 16*ScanPhaseShiftB)
  1:618: ScanMag1*1 ScanPhase1 + (15*ScanPhaseShiftA + 17*ScanPhaseShiftB)
  1:619: ScanMag1*1 ScanPhase1 + (15*ScanPhaseShiftA + 18*ScanPhaseShiftB)
  1:620: ScanMag1*1 ScanPhase1 + (15*ScanPhaseShiftA + 19*ScanPhaseShiftB)
  1:621: ScanMag1*1 ScanPhase1 + (15*ScanPhaseShiftA + 20*ScanPhaseShiftB)
  1:622: ScanMag1*1 ScanPhase1 + (15*ScanPhaseShiftA + 21*ScanPhaseShiftB)
  1:623: ScanMag1*1 ScanPhase1 + (15*ScanPhaseShiftA + 22*ScanPhaseShiftB)
  1:624: ScanMag1*1 ScanPhase1 + (15*ScanPhaseShiftA + 23*ScanPhaseShiftB)
  1:625: ScanMag1*1 ScanPhase1 + (15*ScanPhaseShiftA + 24*ScanPhaseShiftB)
  1:626: ScanMag1*1 ScanPhase1 + (15*ScanPhaseShiftA + 25*ScanPhaseShiftB)
  1:627: ScanMag1*1 ScanPhase1 + (15*ScanPhaseShiftA + 26*ScanPhaseShiftB)
  1:628: ScanMag1*1 ScanPhase1 + (15*ScanPhaseShiftA + 27*ScanPhaseShiftB)
  1:629: ScanMag1*1 ScanPhase1 + (15*ScanPhaseShiftA + 28*ScanPhaseShiftB)
  1:630: ScanMag1*1 ScanPhase1 + (15*ScanPhaseShiftA + 29*ScanPhaseShiftB)
  1:631: ScanMag1*1 ScanPhase1 + (15*ScanPhaseShiftA + 30*ScanPhaseShiftB)
  1:632: ScanMag1*1 ScanPhase1 + (15*ScanPhaseShiftA + 31*ScanPhaseShiftB)
  1:633: ScanMag1*1 ScanPhase1 + (15*ScanPhaseShiftA + 32*ScanPhaseShiftB)
  1:634: ScanMag1*1 ScanPhase1 + (15*ScanPhaseShiftA + 33*ScanPhaseShiftB)
  1:635: ScanMag1*1 ScanPhase1 + (15*ScanPhaseShiftA + 34*ScanPhaseShiftB)
  1:636: ScanMag1*1 ScanPhase1 + (15*ScanPhaseShiftA + 35*ScanPhaseShiftB)
  1:637: ScanMag1*1 ScanPhase1 + (15*ScanPhaseShiftA + 36*ScanPhaseShiftB)
  1:638: ScanMag1*1 ScanPhase1 + (15*ScanPhaseShiftA + 37*ScanPhaseShiftB)
  1:639: ScanMag1*1 ScanPhase1 + (15*ScanPhaseShiftA + 38*ScanPhaseShiftB)
  1:640: ScanMag1*1 ScanPhase1 + (15*ScanPhaseShiftA + 39*ScanPhaseShiftB)
  1:641: ScanMag1*1 ScanPhase1 + (16*ScanPhaseShiftA + 0*ScanPhaseShiftB)
  1:642: ScanMag1*1 ScanPhase1 + (16*ScanPhaseShiftA + 1*ScanPhaseShiftB)
  1:643: ScanMag1*1 ScanPhase1 + (16*ScanPhaseShiftA + 2*ScanPhaseShiftB)
  1:644: ScanMag1*1 ScanPhase1 + (16*ScanPhaseShiftA + 3*ScanPhaseShiftB)
  1:645: ScanMag1*1 ScanPhase1 + (16*ScanPhaseShiftA + 4*ScanPhaseShiftB)
  1:646: ScanMag1*1 ScanPhase1 + (16*ScanPhaseShiftA + 5*ScanPhaseShiftB)
  1:647: ScanMag1*1 ScanPhase1 + (16*ScanPhaseShiftA + 6*ScanPhaseShiftB)
  1:648: ScanMag1*1 ScanPhase1 + (16*ScanPhaseShiftA + 7*ScanPhaseShiftB)
  1:649: ScanMag1*1 ScanPhase1 + (16*ScanPhaseShiftA + 8*ScanPhaseShiftB)
  1:650: ScanMag1*1 ScanPhase1 + (16*ScanPhaseShiftA + 9*ScanPhaseShiftB)
  1:651: ScanMag1*1 ScanPhase1 + (16*ScanPhaseShiftA + 10*ScanPhaseShiftB)
  1:652: ScanMag1*1 ScanPhase1 + (16*ScanPhaseShiftA + 11*ScanPhaseShiftB)
  1:653: ScanMag1*1 ScanPhase1 + (16*ScanPhaseShiftA + 12*ScanPhaseShiftB)
  1:654: ScanMag1*1 ScanPhase1 + (16*ScanPhaseShiftA + 13*ScanPhaseShiftB)
  1:655: ScanMag1*1 ScanPhase1 + (16*ScanPhaseShiftA + 14*ScanPhaseShiftB)
  1:656: ScanMag1*1 ScanPhase1 + (16*ScanPhaseShiftA + 15*ScanPhaseShiftB)
  1:657: ScanMag1*1 ScanPhase1 + (16*ScanPhaseShiftA + 16*ScanPhaseShiftB)
  1:658: ScanMag1*1 ScanPhase1 + (16*ScanPhaseShiftA + 17*ScanPhaseShiftB)
  1:659: ScanMag1*1 ScanPhase1 + (16*ScanPhaseShiftA + 18*ScanPhaseShiftB)
  1:660: ScanMag1*1 ScanPhase1 + (16*ScanPhaseShiftA + 19*ScanPhaseShiftB)
  1:661: ScanMag1*1 ScanPhase1 + (16*ScanPhaseShiftA + 20*ScanPhaseShiftB)
  1:662: ScanMag1*1 ScanPhase1 + (16*ScanPhaseShiftA + 21*ScanPhaseShiftB)
  1:663: ScanMag1*1 ScanPhase1 + (16*ScanPhaseShiftA + 22*ScanPhaseShiftB)
  1:664: ScanMag1*1 ScanPhase1 + (16*ScanPhaseShiftA + 23*ScanPhaseShiftB)
  1:665: ScanMag1*1 ScanPhase1 + (16*ScanPhaseShiftA + 24*ScanPhaseShiftB)
  1:666: ScanMag1*1 ScanPhase1 + (16*ScanPhaseShiftA + 25*ScanPhaseShiftB)
  1:667: ScanMag1*1 ScanPhase1 + (16*ScanPhaseShiftA + 26*ScanPhaseShiftB)
  1:668: ScanMag1*1 ScanPhase1 + (16*ScanPhaseShiftA + 27*ScanPhaseShiftB)
  1:669: ScanMag1*1 ScanPhase1 + (16*ScanPhaseShiftA + 28*ScanPhaseShiftB)
  1:670: ScanMag1*1 ScanPhase1 + (16*ScanPhaseShiftA + 29*ScanPhaseShiftB)
  1:671: ScanMag1*1 ScanPhase1 + (16*ScanPhaseShiftA + 30*ScanPhaseShiftB)
  1:672: ScanMag1*1 ScanPhase1 + (16*ScanPhaseShiftA + 31*ScanPhaseShiftB)
  1:673: ScanMag1*1 ScanPhase1 + (16*ScanPhaseShiftA + 32*ScanPhaseShiftB)
  1:674: ScanMag1*1 ScanPhase1 + (16*ScanPhaseShiftA + 33*ScanPhaseShiftB)
  1:675: ScanMag1*1 ScanPhase1 + (16*ScanPhaseShiftA + 34*ScanPhaseShiftB)
  1:676: ScanMag1*1 ScanPhase1 + (16*ScanPhaseShiftA + 35*ScanPhaseShiftB)
  1:677: ScanMag1*1 ScanPhase1 + (16*ScanPhaseShiftA + 36*ScanPhaseShiftB)
  1:678: ScanMag1*1 ScanPhase1 + (16*ScanPhaseShiftA + 37*ScanPhaseShiftB)
  1:679: ScanMag1*1 ScanPhase1 + (16*ScanPhaseShiftA + 38*ScanPhaseShiftB)
  1:680: ScanMag1*1 ScanPhase1 + (16*ScanPhaseShiftA + 39*ScanPhaseShiftB)
  1:681: ScanMag1*1 ScanPhase1 + (17*ScanPhaseShiftA + 0*ScanPhaseShiftB)
  1:682: ScanMag1*1 ScanPhase1 + (17*ScanPhaseShiftA + 1*ScanPhaseShiftB)
  1:683: ScanMag1*1 ScanPhase1 + (17*ScanPhaseShiftA + 2*ScanPhaseShiftB)
  1:684: ScanMag1*1 ScanPhase1 + (17*ScanPhaseShiftA + 3*ScanPhaseShiftB)
  1:685: ScanMag1*1 ScanPhase1 + (17*ScanPhaseShiftA + 4*ScanPhaseShiftB)
  1:686: ScanMag1*1 ScanPhase1 + (17*ScanPhaseShiftA + 5*ScanPhaseShiftB)
  1:687: ScanMag1*1 ScanPhase1 + (17*ScanPhaseShiftA + 6*ScanPhaseShiftB)
  1:688: ScanMag1*1 ScanPhase1 + (17*ScanPhaseShiftA + 7*ScanPhaseShiftB)
  1:689: ScanMag1*1 ScanPhase1 + (17*ScanPhaseShiftA + 8*ScanPhaseShiftB)
  1:690: ScanMag1*1 ScanPhase1 + (17*ScanPhaseShiftA + 9*ScanPhaseShiftB)
  1:691: ScanMag1*1 ScanPhase1 + (17*ScanPhaseShiftA + 10*ScanPhaseShiftB)
  1:692: ScanMag1*1 ScanPhase1 + (17*ScanPhaseShiftA + 11*ScanPhaseShiftB)
  1:693: ScanMag1*1 ScanPhase1 + (17*ScanPhaseShiftA + 12*ScanPhaseShiftB)
  1:694: ScanMag1*1 ScanPhase1 + (17*ScanPhaseShiftA + 13*ScanPhaseShiftB)
  1:695: ScanMag1*1 ScanPhase1 + (17*ScanPhaseShiftA + 14*ScanPhaseShiftB)
  1:696: ScanMag1*1 ScanPhase1 + (17*ScanPhaseShiftA + 15*ScanPhaseShiftB)
  1:697: ScanMag1*1 ScanPhase1 + (17*ScanPhaseShiftA + 16*ScanPhaseShiftB)
  1:698: ScanMag1*1 ScanPhase1 + (17*ScanPhaseShiftA + 17*ScanPhaseShiftB)
  1:699: ScanMag1*1 ScanPhase1 + (17*ScanPhaseShiftA + 18*ScanPhaseShiftB)
  1:700: ScanMag1*1 ScanPhase1 + (17*ScanPhaseShiftA + 19*ScanPhaseShiftB)
  1:701: ScanMag1*1 ScanPhase1 + (17*ScanPhaseShiftA + 20*ScanPhaseShiftB)
  1:702: ScanMag1*1 ScanPhase1 + (17*ScanPhaseShiftA + 21*ScanPhaseShiftB)
  1:703: ScanMag1*1 ScanPhase1 + (17*ScanPhaseShiftA + 22*ScanPhaseShiftB)
  1:704: ScanMag1*1 ScanPhase1 + (17*ScanPhaseShiftA + 23*ScanPhaseShiftB)
  1:705: ScanMag1*1 ScanPhase1 + (17*ScanPhaseShiftA + 24*ScanPhaseShiftB)
  1:706: ScanMag1*1 ScanPhase1 + (17*ScanPhaseShiftA + 25*ScanPhaseShiftB)
  1:707: ScanMag1*1 ScanPhase1 + (17*ScanPhaseShiftA + 26*ScanPhaseShiftB)
  1:708: ScanMag1*1 ScanPhase1 + (17*ScanPhaseShiftA + 27*ScanPhaseShiftB)
  1:709: ScanMag1*1 ScanPhase1 + (17*ScanPhaseShiftA + 28*ScanPhaseShiftB)
  1:710: ScanMag1*1 ScanPhase1 + (17*ScanPhaseShiftA + 29*ScanPhaseShiftB)
  1:711: ScanMag1*1 ScanPhase1 + (17*ScanPhaseShiftA + 30*ScanPhaseShiftB)
  1:712: ScanMag1*1 ScanPhase1 + (17*ScanPhaseShiftA + 31*ScanPhaseShiftB)
  1:713: ScanMag1*1 ScanPhase1 + (17*ScanPhaseShiftA + 32*ScanPhaseShiftB)
  1:714: ScanMag1*1 ScanPhase1 + (17*ScanPhaseShiftA + 33*ScanPhaseShiftB)
  1:715: ScanMag1*1 ScanPhase1 + (17*ScanPhaseShiftA + 34*ScanPhaseShiftB)
  1:716: ScanMag1*1 ScanPhase1 + (17*ScanPhaseShiftA + 35*ScanPhaseShiftB)
  1:717: ScanMag1*1 ScanPhase1 + (17*ScanPhaseShiftA + 36*ScanPhaseShiftB)
  1:718: ScanMag1*1 ScanPhase1 + (17*ScanPhaseShiftA + 37*ScanPhaseShiftB)
  1:719: ScanMag1*1 ScanPhase1 + (17*ScanPhaseShiftA + 38*ScanPhaseShiftB)
  1:720: ScanMag1*1 ScanPhase1 + (17*ScanPhaseShiftA + 39*ScanPhaseShiftB)
  1:721: ScanMag1*1 ScanPhase1 + (18*ScanPhaseShiftA + 0*ScanPhaseShiftB)
  1:722: ScanMag1*1 ScanPhase1 + (18*ScanPhaseShiftA + 1*ScanPhaseShiftB)
  1:723: ScanMag1*1 ScanPhase1 + (18*ScanPhaseShiftA + 2*ScanPhaseShiftB)
  1:724: ScanMag1*1 ScanPhase1 + (18*ScanPhaseShiftA + 3*ScanPhaseShiftB)
  1:725: ScanMag1*1 ScanPhase1 + (18*ScanPhaseShiftA + 4*ScanPhaseShiftB)
  1:726: ScanMag1*1 ScanPhase1 + (18*ScanPhaseShiftA + 5*ScanPhaseShiftB)
  1:727: ScanMag1*1 ScanPhase1 + (18*ScanPhaseShiftA + 6*ScanPhaseShiftB)
  1:728: ScanMag1*1 ScanPhase1 + (18*ScanPhaseShiftA + 7*ScanPhaseShiftB)
  1:729: ScanMag1*1 ScanPhase1 + (18*ScanPhaseShiftA + 8*ScanPhaseShiftB)
  1:730: ScanMag1*1 ScanPhase1 + (18*ScanPhaseShiftA + 9*ScanPhaseShiftB)
  1:731: ScanMag1*1 ScanPhase1 + (18*ScanPhaseShiftA + 10*ScanPhaseShiftB)
  1:732: ScanMag1*1 ScanPhase1 + (18*ScanPhaseShiftA + 11*ScanPhaseShiftB)
  1:733: ScanMag1*1 ScanPhase1 + (18*ScanPhaseShiftA + 12*ScanPhaseShiftB)
  1:734: ScanMag1*1 ScanPhase1 + (18*ScanPhaseShiftA + 13*ScanPhaseShiftB)
  1:735: ScanMag1*1 ScanPhase1 + (18*ScanPhaseShiftA + 14*ScanPhaseShiftB)
  1:736: ScanMag1*1 ScanPhase1 + (18*ScanPhaseShiftA + 15*ScanPhaseShiftB)
  1:737: ScanMag1*1 ScanPhase1 + (18*ScanPhaseShiftA + 16*ScanPhaseShiftB)
  1:738: ScanMag1*1 ScanPhase1 + (18*ScanPhaseShiftA + 17*ScanPhaseShiftB)
  1:739: ScanMag1*1 ScanPhase1 + (18*ScanPhaseShiftA + 18*ScanPhaseShiftB)
  1:740: ScanMag1*1 ScanPhase1 + (18*ScanPhaseShiftA + 19*ScanPhaseShiftB)
  1:741: ScanMag1*1 ScanPhase1 + (18*ScanPhaseShiftA + 20*ScanPhaseShiftB)
  1:742: ScanMag1*1 ScanPhase1 + (18*ScanPhaseShiftA + 21*ScanPhaseShiftB)
  1:743: ScanMag1*1 ScanPhase1 + (18*ScanPhaseShiftA + 22*ScanPhaseShiftB)
  1:744: ScanMag1*1 ScanPhase1 + (18*ScanPhaseShiftA + 23*ScanPhaseShiftB)
  1:745: ScanMag1*1 ScanPhase1 + (18*ScanPhaseShiftA + 24*ScanPhaseShiftB)
  1:746: ScanMag1*1 ScanPhase1 + (18*ScanPhaseShiftA + 25*ScanPhaseShiftB)
  1:747: ScanMag1*1 ScanPhase1 + (18*ScanPhaseShiftA + 26*ScanPhaseShiftB)
  1:748: ScanMag1*1 ScanPhase1 + (18*ScanPhaseShiftA + 27*ScanPhaseShiftB)
  1:749: ScanMag1*1 ScanPhase1 + (18*ScanPhaseShiftA + 28*ScanPhaseShiftB)
  1:750: ScanMag1*1 ScanPhase1 + (18*ScanPhaseShiftA + 29*ScanPhaseShiftB)
  1:751: ScanMag1*1 ScanPhase1 + (18*ScanPhaseShiftA + 30*ScanPhaseShiftB)
  1:752: ScanMag1*1 ScanPhase1 + (18*ScanPhaseShiftA + 31*ScanPhaseShiftB)
  1:753: ScanMag1*1 ScanPhase1 + (18*ScanPhaseShiftA + 32*ScanPhaseShiftB)
  1:754: ScanMag1*1 ScanPhase1 + (18*ScanPhaseShiftA + 33*ScanPhaseShiftB)
  1:755: ScanMag1*1 ScanPhase1 + (18*ScanPhaseShiftA + 34*ScanPhaseShiftB)
  1:756: ScanMag1*1 ScanPhase1 + (18*ScanPhaseShiftA + 35*ScanPhaseShiftB)
  1:757: ScanMag1*1 ScanPhase1 + (18*ScanPhaseShiftA + 36*ScanPhaseShiftB)
  1:758: ScanMag1*1 ScanPhase1 + (18*ScanPhaseShiftA + 37*ScanPhaseShiftB)
  1:759: ScanMag1*1 ScanPhase1 + (18*ScanPhaseShiftA + 38*ScanPhaseShiftB)
  1:760: ScanMag1*1 ScanPhase1 + (18*ScanPhaseShiftA + 39*ScanPhaseShiftB)
  1:761: ScanMag1*1 ScanPhase1 + (19*ScanPhaseShiftA + 0*ScanPhaseShiftB)
  1:762: ScanMag1*1 ScanPhase1 + (19*ScanPhaseShiftA + 1*ScanPhaseShiftB)
  1:763: ScanMag1*1 ScanPhase1 + (19*ScanPhaseShiftA + 2*ScanPhaseShiftB)
  1:764: ScanMag1*1 ScanPhase1 + (19*ScanPhaseShiftA + 3*ScanPhaseShiftB)
  1:765: ScanMag1*1 ScanPhase1 + (19*ScanPhaseShiftA + 4*ScanPhaseShiftB)
  1:766: ScanMag1*1 ScanPhase1 + (19*ScanPhaseShiftA + 5*ScanPhaseShiftB)
  1:767: ScanMag1*1 ScanPhase1 + (19*ScanPhaseShiftA + 6*ScanPhaseShiftB)
  1:768: ScanMag1*1 ScanPhase1 + (19*ScanPhaseShiftA + 7*ScanPhaseShiftB)
  1:769: ScanMag1*1 ScanPhase1 + (19*ScanPhaseShiftA + 8*ScanPhaseShiftB)
  1:770: ScanMag1*1 ScanPhase1 + (19*ScanPhaseShiftA + 9*ScanPhaseShiftB)
  1:771: ScanMag1*1 ScanPhase1 + (19*ScanPhaseShiftA + 10*ScanPhaseShiftB)
  1:772: ScanMag1*1 ScanPhase1 + (19*ScanPhaseShiftA + 11*ScanPhaseShiftB)
  1:773: ScanMag1*1 ScanPhase1 + (19*ScanPhaseShiftA + 12*ScanPhaseShiftB)
  1:774: ScanMag1*1 ScanPhase1 + (19*ScanPhaseShiftA + 13*ScanPhaseShiftB)
  1:775: ScanMag1*1 ScanPhase1 + (19*ScanPhaseShiftA + 14*ScanPhaseShiftB)
  1:776: ScanMag1*1 ScanPhase1 + (19*ScanPhaseShiftA + 15*ScanPhaseShiftB)
  1:777: ScanMag1*1 ScanPhase1 + (19*ScanPhaseShiftA + 16*ScanPhaseShiftB)
  1:778: ScanMag1*1 ScanPhase1 + (19*ScanPhaseShiftA + 17*ScanPhaseShiftB)
  1:779: ScanMag1*1 ScanPhase1 + (19*ScanPhaseShiftA + 18*ScanPhaseShiftB)
  1:780: ScanMag1*1 ScanPhase1 + (19*ScanPhaseShiftA + 19*ScanPhaseShiftB)
  1:781: ScanMag1*1 ScanPhase1 + (19*ScanPhaseShiftA + 20*ScanPhaseShiftB)
  1:782: ScanMag1*1 ScanPhase1 + (19*ScanPhaseShiftA + 21*ScanPhaseShiftB)
  1:783: ScanMag1*1 ScanPhase1 + (19*ScanPhaseShiftA + 22*ScanPhaseShiftB)
  1:784: ScanMag1*1 ScanPhase1 + (19*ScanPhaseShiftA + 23*ScanPhaseShiftB)
  1:785: ScanMag1*1 ScanPhase1 + (19*ScanPhaseShiftA + 24*ScanPhaseShiftB)
  1:786: ScanMag1*1 ScanPhase1 + (19*ScanPhaseShiftA + 25*ScanPhaseShiftB)
  1:787: ScanMag1*1 ScanPhase1 + (19*ScanPhaseShiftA + 26*ScanPhaseShiftB)
  1:788: ScanMag1*1 ScanPhase1 + (19*ScanPhaseShiftA + 27*ScanPhaseShiftB)
  1:789: ScanMag1*1 ScanPhase1 + (19*ScanPhaseShiftA + 28*ScanPhaseShiftB)
  1:790: ScanMag1*1 ScanPhase1 + (19*ScanPhaseShiftA + 29*ScanPhaseShiftB)
  1:791: ScanMag1*1 ScanPhase1 + (19*ScanPhaseShiftA + 30*ScanPhaseShiftB)
  1:792: ScanMag1*1 ScanPhase1 + (19*ScanPhaseShiftA + 31*ScanPhaseShiftB)
  1:793: ScanMag1*1 ScanPhase1 + (19*ScanPhaseShiftA + 32*ScanPhaseShiftB)
  1:794: ScanMag1*1 ScanPhase1 + (19*ScanPhaseShiftA + 33*ScanPhaseShiftB)
  1:795: ScanMag1*1 ScanPhase1 + (19*ScanPhaseShiftA + 34*ScanPhaseShiftB)
  1:796: ScanMag1*1 ScanPhase1 + (19*ScanPhaseShiftA + 35*ScanPhaseShiftB)
  1:797: ScanMag1*1 ScanPhase1 + (19*ScanPhaseShiftA + 36*ScanPhaseShiftB)
  1:798: ScanMag1*1 ScanPhase1 + (19*ScanPhaseShiftA + 37*ScanPhaseShiftB)
  1:799: ScanMag1*1 ScanPhase1 + (19*ScanPhaseShiftA + 38*ScanPhaseShiftB)
  1:800: ScanMag1*1 ScanPhase1 + (19*ScanPhaseShiftA + 39*ScanPhaseShiftB)
  1:801: ScanMag1*1 ScanPhase1 + (20*ScanPhaseShiftA + 0*ScanPhaseShiftB)
  1:802: ScanMag1*1 ScanPhase1 + (20*ScanPhaseShiftA + 1*ScanPhaseShiftB)
  1:803: ScanMag1*1 ScanPhase1 + (20*ScanPhaseShiftA + 2*ScanPhaseShiftB)
  1:804: ScanMag1*1 ScanPhase1 + (20*ScanPhaseShiftA + 3*ScanPhaseShiftB)
  1:805: ScanMag1*1 ScanPhase1 + (20*ScanPhaseShiftA + 4*ScanPhaseShiftB)
  1:806: ScanMag1*1 ScanPhase1 + (20*ScanPhaseShiftA + 5*ScanPhaseShiftB)
  1:807: ScanMag1*1 ScanPhase1 + (20*ScanPhaseShiftA + 6*ScanPhaseShiftB)
  1:808: ScanMag1*1 ScanPhase1 + (20*ScanPhaseShiftA + 7*ScanPhaseShiftB)
  1:809: ScanMag1*1 ScanPhase1 + (20*ScanPhaseShiftA + 8*ScanPhaseShiftB)
  1:810: ScanMag1*1 ScanPhase1 + (20*ScanPhaseShiftA + 9*ScanPhaseShiftB)
  1:811: ScanMag1*1 ScanPhase1 + (20*ScanPhaseShiftA + 10*ScanPhaseShiftB)
  1:812: ScanMag1*1 ScanPhase1 + (20*ScanPhaseShiftA + 11*ScanPhaseShiftB)
  1:813: ScanMag1*1 ScanPhase1 + (20*ScanPhaseShiftA + 12*ScanPhaseShiftB)
  1:814: ScanMag1*1 ScanPhase1 + (20*ScanPhaseShiftA + 13*ScanPhaseShiftB)
  1:815: ScanMag1*1 ScanPhase1 + (20*ScanPhaseShiftA + 14*ScanPhaseShiftB)
  1:816: ScanMag1*1 ScanPhase1 + (20*ScanPhaseShiftA + 15*ScanPhaseShiftB)
  1:817: ScanMag1*1 ScanPhase1 + (20*ScanPhaseShiftA + 16*ScanPhaseShiftB)
  1:818: ScanMag1*1 ScanPhase1 + (20*ScanPhaseShiftA + 17*ScanPhaseShiftB)
  1:819: ScanMag1*1 ScanPhase1 + (20*ScanPhaseShiftA + 18*ScanPhaseShiftB)
  1:820: ScanMag1*1 ScanPhase1 + (20*ScanPhaseShiftA + 19*ScanPhaseShiftB)
  1:821: ScanMag1*1 ScanPhase1 + (20*ScanPhaseShiftA + 20*ScanPhaseShiftB)
  1:822: ScanMag1*1 ScanPhase1 + (20*ScanPhaseShiftA + 21*ScanPhaseShiftB)
  1:823: ScanMag1*1 ScanPhase1 + (20*ScanPhaseShiftA + 22*ScanPhaseShiftB)
  1:824: ScanMag1*1 ScanPhase1 + (20*ScanPhaseShiftA + 23*ScanPhaseShiftB)
  1:825: ScanMag1*1 ScanPhase1 + (20*ScanPhaseShiftA + 24*ScanPhaseShiftB)
  1:826: ScanMag1*1 ScanPhase1 + (20*ScanPhaseShiftA + 25*ScanPhaseShiftB)
  1:827: ScanMag1*1 ScanPhase1 + (20*ScanPhaseShiftA + 26*ScanPhaseShiftB)
  1:828: ScanMag1*1 ScanPhase1 + (20*ScanPhaseShiftA + 27*ScanPhaseShiftB)
  1:829: ScanMag1*1 ScanPhase1 + (20*ScanPhaseShiftA + 28*ScanPhaseShiftB)
  1:830: ScanMag1*1 ScanPhase1 + (20*ScanPhaseShiftA + 29*ScanPhaseShiftB)
  1:831: ScanMag1*1 ScanPhase1 + (20*ScanPhaseShiftA + 30*ScanPhaseShiftB)
  1:832: ScanMag1*1 ScanPhase1 + (20*ScanPhaseShiftA + 31*ScanPhaseShiftB)
  1:833: ScanMag1*1 ScanPhase1 + (20*ScanPhaseShiftA + 32*ScanPhaseShiftB)
  1:834: ScanMag1*1 ScanPhase1 + (20*ScanPhaseShiftA + 33*ScanPhaseShiftB)
  1:835: ScanMag1*1 ScanPhase1 + (20*ScanPhaseShiftA + 34*ScanPhaseShiftB)
  1:836: ScanMag1*1 ScanPhase1 + (20*ScanPhaseShiftA + 35*ScanPhaseShiftB)
  1:837: ScanMag1*1 ScanPhase1 + (20*ScanPhaseShiftA + 36*ScanPhaseShiftB)
  1:838: ScanMag1*1 ScanPhase1 + (20*ScanPhaseShiftA + 37*ScanPhaseShiftB)
  1:839: ScanMag1*1 ScanPhase1 + (20*ScanPhaseShiftA + 38*ScanPhaseShiftB)
  1:840: ScanMag1*1 ScanPhase1 + (20*ScanPhaseShiftA + 39*ScanPhaseShiftB)
  1:841: ScanMag1*1 ScanPhase1 + (21*ScanPhaseShiftA + 0*ScanPhaseShiftB)
  1:842: ScanMag1*1 ScanPhase1 + (21*ScanPhaseShiftA + 1*ScanPhaseShiftB)
  1:843: ScanMag1*1 ScanPhase1 + (21*ScanPhaseShiftA + 2*ScanPhaseShiftB)
  1:844: ScanMag1*1 ScanPhase1 + (21*ScanPhaseShiftA + 3*ScanPhaseShiftB)
  1:845: ScanMag1*1 ScanPhase1 + (21*ScanPhaseShiftA + 4*ScanPhaseShiftB)
  1:846: ScanMag1*1 ScanPhase1 + (21*ScanPhaseShiftA + 5*ScanPhaseShiftB)
  1:847: ScanMag1*1 ScanPhase1 + (21*ScanPhaseShiftA + 6*ScanPhaseShiftB)
  1:848: ScanMag1*1 ScanPhase1 + (21*ScanPhaseShiftA + 7*ScanPhaseShiftB)
  1:849: ScanMag1*1 ScanPhase1 + (21*ScanPhaseShiftA + 8*ScanPhaseShiftB)
  1:850: ScanMag1*1 ScanPhase1 + (21*ScanPhaseShiftA + 9*ScanPhaseShiftB)
  1:851: ScanMag1*1 ScanPhase1 + (21*ScanPhaseShiftA + 10*ScanPhaseShiftB)
  1:852: ScanMag1*1 ScanPhase1 + (21*ScanPhaseShiftA + 11*ScanPhaseShiftB)
  1:853: ScanMag1*1 ScanPhase1 + (21*ScanPhaseShiftA + 12*ScanPhaseShiftB)
  1:854: ScanMag1*1 ScanPhase1 + (21*ScanPhaseShiftA + 13*ScanPhaseShiftB)
  1:855: ScanMag1*1 ScanPhase1 + (21*ScanPhaseShiftA + 14*ScanPhaseShiftB)
  1:856: ScanMag1*1 ScanPhase1 + (21*ScanPhaseShiftA + 15*ScanPhaseShiftB)
  1:857: ScanMag1*1 ScanPhase1 + (21*ScanPhaseShiftA + 16*ScanPhaseShiftB)
  1:858: ScanMag1*1 ScanPhase1 + (21*ScanPhaseShiftA + 17*ScanPhaseShiftB)
  1:859: ScanMag1*1 ScanPhase1 + (21*ScanPhaseShiftA + 18*ScanPhaseShiftB)
  1:860: ScanMag1*1 ScanPhase1 + (21*ScanPhaseShiftA + 19*ScanPhaseShiftB)
  1:861: ScanMag1*1 ScanPhase1 + (21*ScanPhaseShiftA + 20*ScanPhaseShiftB)
  1:862: ScanMag1*1 ScanPhase1 + (21*ScanPhaseShiftA + 21*ScanPhaseShiftB)
  1:863: ScanMag1*1 ScanPhase1 + (21*ScanPhaseShiftA + 22*ScanPhaseShiftB)
  1:864: ScanMag1*1 ScanPhase1 + (21*ScanPhaseShiftA + 23*ScanPhaseShiftB)
  1:865: ScanMag1*1 ScanPhase1 + (21*ScanPhaseShiftA + 24*ScanPhaseShiftB)
  1:866: ScanMag1*1 ScanPhase1 + (21*ScanPhaseShiftA + 25*ScanPhaseShiftB)
  1:867: ScanMag1*1 ScanPhase1 + (21*ScanPhaseShiftA + 26*ScanPhaseShiftB)
  1:868: ScanMag1*1 ScanPhase1 + (21*ScanPhaseShiftA + 27*ScanPhaseShiftB)
  1:869: ScanMag1*1 ScanPhase1 + (21*ScanPhaseShiftA + 28*ScanPhaseShiftB)
  1:870: ScanMag1*1 ScanPhase1 + (21*ScanPhaseShiftA + 29*ScanPhaseShiftB)
  1:871: ScanMag1*1 ScanPhase1 + (21*ScanPhaseShiftA + 30*ScanPhaseShiftB)
  1:872: ScanMag1*1 ScanPhase1 + (21*ScanPhaseShiftA + 31*ScanPhaseShiftB)
  1:873: ScanMag1*1 ScanPhase1 + (21*ScanPhaseShiftA + 32*ScanPhaseShiftB)
  1:874: ScanMag1*1 ScanPhase1 + (21*ScanPhaseShiftA + 33*ScanPhaseShiftB)
  1:875: ScanMag1*1 ScanPhase1 + (21*ScanPhaseShiftA + 34*ScanPhaseShiftB)
  1:876: ScanMag1*1 ScanPhase1 + (21*ScanPhaseShiftA + 35*ScanPhaseShiftB)
  1:877: ScanMag1*1 ScanPhase1 + (21*ScanPhaseShiftA + 36*ScanPhaseShiftB)
  1:878: ScanMag1*1 ScanPhase1 + (21*ScanPhaseShiftA + 37*ScanPhaseShiftB)
  1:879: ScanMag1*1 ScanPhase1 + (21*ScanPhaseShiftA + 38*ScanPhaseShiftB)
  1:880: ScanMag1*1 ScanPhase1 + (21*ScanPhaseShiftA + 39*ScanPhaseShiftB)
  1:881: ScanMag1*1 ScanPhase1 + (22*ScanPhaseShiftA + 0*ScanPhaseShiftB)
  1:882: ScanMag1*1 ScanPhase1 + (22*ScanPhaseShiftA + 1*ScanPhaseShiftB)
  1:883: ScanMag1*1 ScanPhase1 + (22*ScanPhaseShiftA + 2*ScanPhaseShiftB)
  1:884: ScanMag1*1 ScanPhase1 + (22*ScanPhaseShiftA + 3*ScanPhaseShiftB)
  1:885: ScanMag1*1 ScanPhase1 + (22*ScanPhaseShiftA + 4*ScanPhaseShiftB)
  1:886: ScanMag1*1 ScanPhase1 + (22*ScanPhaseShiftA + 5*ScanPhaseShiftB)
  1:887: ScanMag1*1 ScanPhase1 + (22*ScanPhaseShiftA + 6*ScanPhaseShiftB)
  1:888: ScanMag1*1 ScanPhase1 + (22*ScanPhaseShiftA + 7*ScanPhaseShiftB)
  1:889: ScanMag1*1 ScanPhase1 + (22*ScanPhaseShiftA + 8*ScanPhaseShiftB)
  1:890: ScanMag1*1 ScanPhase1 + (22*ScanPhaseShiftA + 9*ScanPhaseShiftB)
  1:891: ScanMag1*1 ScanPhase1 + (22*ScanPhaseShiftA + 10*ScanPhaseShiftB)
  1:892: ScanMag1*1 ScanPhase1 + (22*ScanPhaseShiftA + 11*ScanPhaseShiftB)
  1:893: ScanMag1*1 ScanPhase1 + (22*ScanPhaseShiftA + 12*ScanPhaseShiftB)
  1:894: ScanMag1*1 ScanPhase1 + (22*ScanPhaseShiftA + 13*ScanPhaseShiftB)
  1:895: ScanMag1*1 ScanPhase1 + (22*ScanPhaseShiftA + 14*ScanPhaseShiftB)
  1:896: ScanMag1*1 ScanPhase1 + (22*ScanPhaseShiftA + 15*ScanPhaseShiftB)
  1:897: ScanMag1*1 ScanPhase1 + (22*ScanPhaseShiftA + 16*ScanPhaseShiftB)
  1:898: ScanMag1*1 ScanPhase1 + (22*ScanPhaseShiftA + 17*ScanPhaseShiftB)
  1:899: ScanMag1*1 ScanPhase1 + (22*ScanPhaseShiftA + 18*ScanPhaseShiftB)
  1:900: ScanMag1*1 ScanPhase1 + (22*ScanPhaseShiftA + 19*ScanPhaseShiftB)
  1:901: ScanMag1*1 ScanPhase1 + (22*ScanPhaseShiftA + 20*ScanPhaseShiftB)
  1:902: ScanMag1*1 ScanPhase1 + (22*ScanPhaseShiftA + 21*ScanPhaseShiftB)
  1:903: ScanMag1*1 ScanPhase1 + (22*ScanPhaseShiftA + 22*ScanPhaseShiftB)
  1:904: ScanMag1*1 ScanPhase1 + (22*ScanPhaseShiftA + 23*ScanPhaseShiftB)
  1:905: ScanMag1*1 ScanPhase1 + (22*ScanPhaseShiftA + 24*ScanPhaseShiftB)
  1:906: ScanMag1*1 ScanPhase1 + (22*ScanPhaseShiftA + 25*ScanPhaseShiftB)
  1:907: ScanMag1*1 ScanPhase1 + (22*ScanPhaseShiftA + 26*ScanPhaseShiftB)
  1:908: ScanMag1*1 ScanPhase1 + (22*ScanPhaseShiftA + 27*ScanPhaseShiftB)
  1:909: ScanMag1*1 ScanPhase1 + (22*ScanPhaseShiftA + 28*ScanPhaseShiftB)
  1:910: ScanMag1*1 ScanPhase1 + (22*ScanPhaseShiftA + 29*ScanPhaseShiftB)
  1:911: ScanMag1*1 ScanPhase1 + (22*ScanPhaseShiftA + 30*ScanPhaseShiftB)
  1:912: ScanMag1*1 ScanPhase1 + (22*ScanPhaseShiftA + 31*ScanPhaseShiftB)
  1:913: ScanMag1*1 ScanPhase1 + (22*ScanPhaseShiftA + 32*ScanPhaseShiftB)
  1:914: ScanMag1*1 ScanPhase1 + (22*ScanPhaseShiftA + 33*ScanPhaseShiftB)
  1:915: ScanMag1*1 ScanPhase1 + (22*ScanPhaseShiftA + 34*ScanPhaseShiftB)
  1:916: ScanMag1*1 ScanPhase1 + (22*ScanPhaseShiftA + 35*ScanPhaseShiftB)
  1:917: ScanMag1*1 ScanPhase1 + (22*ScanPhaseShiftA + 36*ScanPhaseShiftB)
  1:918: ScanMag1*1 ScanPhase1 + (22*ScanPhaseShiftA + 37*ScanPhaseShiftB)
  1:919: ScanMag1*1 ScanPhase1 + (22*ScanPhaseShiftA + 38*ScanPhaseShiftB)
  1:920: ScanMag1*1 ScanPhase1 + (22*ScanPhaseShiftA + 39*ScanPhaseShiftB)
  1:921: ScanMag1*1 ScanPhase1 + (23*ScanPhaseShiftA + 0*ScanPhaseShiftB)
  1:922: ScanMag1*1 ScanPhase1 + (23*ScanPhaseShiftA + 1*ScanPhaseShiftB)
  1:923: ScanMag1*1 ScanPhase1 + (23*ScanPhaseShiftA + 2*ScanPhaseShiftB)
  1:924: ScanMag1*1 ScanPhase1 + (23*ScanPhaseShiftA + 3*ScanPhaseShiftB)
  1:925: ScanMag1*1 ScanPhase1 + (23*ScanPhaseShiftA + 4*ScanPhaseShiftB)
  1:926: ScanMag1*1 ScanPhase1 + (23*ScanPhaseShiftA + 5*ScanPhaseShiftB)
  1:927: ScanMag1*1 ScanPhase1 + (23*ScanPhaseShiftA + 6*ScanPhaseShiftB)
  1:928: ScanMag1*1 ScanPhase1 + (23*ScanPhaseShiftA + 7*ScanPhaseShiftB)
  1:929: ScanMag1*1 ScanPhase1 + (23*ScanPhaseShiftA + 8*ScanPhaseShiftB)
  1:930: ScanMag1*1 ScanPhase1 + (23*ScanPhaseShiftA + 9*ScanPhaseShiftB)
  1:931: ScanMag1*1 ScanPhase1 + (23*ScanPhaseShiftA + 10*ScanPhaseShiftB)
  1:932: ScanMag1*1 ScanPhase1 + (23*ScanPhaseShiftA + 11*ScanPhaseShiftB)
  1:933: ScanMag1*1 ScanPhase1 + (23*ScanPhaseShiftA + 12*ScanPhaseShiftB)
  1:934: ScanMag1*1 ScanPhase1 + (23*ScanPhaseShiftA + 13*ScanPhaseShiftB)
  1:935: ScanMag1*1 ScanPhase1 + (23*ScanPhaseShiftA + 14*ScanPhaseShiftB)
  1:936: ScanMag1*1 ScanPhase1 + (23*ScanPhaseShiftA + 15*ScanPhaseShiftB)
  1:937: ScanMag1*1 ScanPhase1 + (23*ScanPhaseShiftA + 16*ScanPhaseShiftB)
  1:938: ScanMag1*1 ScanPhase1 + (23*ScanPhaseShiftA + 17*ScanPhaseShiftB)
  1:939: ScanMag1*1 ScanPhase1 + (23*ScanPhaseShiftA + 18*ScanPhaseShiftB)
  1:940: ScanMag1*1 ScanPhase1 + (23*ScanPhaseShiftA + 19*ScanPhaseShiftB)
  1:941: ScanMag1*1 ScanPhase1 + (23*ScanPhaseShiftA + 20*ScanPhaseShiftB)
  1:942: ScanMag1*1 ScanPhase1 + (23*ScanPhaseShiftA + 21*ScanPhaseShiftB)
  1:943: ScanMag1*1 ScanPhase1 + (23*ScanPhaseShiftA + 22*ScanPhaseShiftB)
  1:944: ScanMag1*1 ScanPhase1 + (23*ScanPhaseShiftA + 23*ScanPhaseShiftB)
  1:945: ScanMag1*1 ScanPhase1 + (23*ScanPhaseShiftA + 24*ScanPhaseShiftB)
  1:946: ScanMag1*1 ScanPhase1 + (23*ScanPhaseShiftA + 25*ScanPhaseShiftB)
  1:947: ScanMag1*1 ScanPhase1 + (23*ScanPhaseShiftA + 26*ScanPhaseShiftB)
  1:948: ScanMag1*1 ScanPhase1 + (23*ScanPhaseShiftA + 27*ScanPhaseShiftB)
  1:949: ScanMag1*1 ScanPhase1 + (23*ScanPhaseShiftA + 28*ScanPhaseShiftB)
  1:950: ScanMag1*1 ScanPhase1 + (23*ScanPhaseShiftA + 29*ScanPhaseShiftB)
  1:951: ScanMag1*1 ScanPhase1 + (23*ScanPhaseShiftA + 30*ScanPhaseShiftB)
  1:952: ScanMag1*1 ScanPhase1 + (23*ScanPhaseShiftA + 31*ScanPhaseShiftB)
  1:953: ScanMag1*1 ScanPhase1 + (23*ScanPhaseShiftA + 32*ScanPhaseShiftB)
  1:954: ScanMag1*1 ScanPhase1 + (23*ScanPhaseShiftA + 33*ScanPhaseShiftB)
  1:955: ScanMag1*1 ScanPhase1 + (23*ScanPhaseShiftA + 34*ScanPhaseShiftB)
  1:956: ScanMag1*1 ScanPhase1 + (23*ScanPhaseShiftA + 35*ScanPhaseShiftB)
  1:957: ScanMag1*1 ScanPhase1 + (23*ScanPhaseShiftA + 36*ScanPhaseShiftB)
  1:958: ScanMag1*1 ScanPhase1 + (23*ScanPhaseShiftA + 37*ScanPhaseShiftB)
  1:959: ScanMag1*1 ScanPhase1 + (23*ScanPhaseShiftA + 38*ScanPhaseShiftB)
  1:960: ScanMag1*1 ScanPhase1 + (23*ScanPhaseShiftA + 39*ScanPhaseShiftB)
  1:961: ScanMag1*1 ScanPhase1 + (24*ScanPhaseShiftA + 0*ScanPhaseShiftB)
  1:962: ScanMag1*1 ScanPhase1 + (24*ScanPhaseShiftA + 1*ScanPhaseShiftB)
  1:963: ScanMag1*1 ScanPhase1 + (24*ScanPhaseShiftA + 2*ScanPhaseShiftB)
  1:964: ScanMag1*1 ScanPhase1 + (24*ScanPhaseShiftA + 3*ScanPhaseShiftB)
  1:965: ScanMag1*1 ScanPhase1 + (24*ScanPhaseShiftA + 4*ScanPhaseShiftB)
  1:966: ScanMag1*1 ScanPhase1 + (24*ScanPhaseShiftA + 5*ScanPhaseShiftB)
  1:967: ScanMag1*1 ScanPhase1 + (24*ScanPhaseShiftA + 6*ScanPhaseShiftB)
  1:968: ScanMag1*1 ScanPhase1 + (24*ScanPhaseShiftA + 7*ScanPhaseShiftB)
  1:969: ScanMag1*1 ScanPhase1 + (24*ScanPhaseShiftA + 8*ScanPhaseShiftB)
  1:970: ScanMag1*1 ScanPhase1 + (24*ScanPhaseShiftA + 9*ScanPhaseShiftB)
  1:971: ScanMag1*1 ScanPhase1 + (24*ScanPhaseShiftA + 10*ScanPhaseShiftB)
  1:972: ScanMag1*1 ScanPhase1 + (24*ScanPhaseShiftA + 11*ScanPhaseShiftB)
  1:973: ScanMag1*1 ScanPhase1 + (24*ScanPhaseShiftA + 12*ScanPhaseShiftB)
  1:974: ScanMag1*1 ScanPhase1 + (24*ScanPhaseShiftA + 13*ScanPhaseShiftB)
  1:975: ScanMag1*1 ScanPhase1 + (24*ScanPhaseShiftA + 14*ScanPhaseShiftB)
  1:976: ScanMag1*1 ScanPhase1 + (24*ScanPhaseShiftA + 15*ScanPhaseShiftB)
  1:977: ScanMag1*1 ScanPhase1 + (24*ScanPhaseShiftA + 16*ScanPhaseShiftB)
  1:978: ScanMag1*1 ScanPhase1 + (24*ScanPhaseShiftA + 17*ScanPhaseShiftB)
  1:979: ScanMag1*1 ScanPhase1 + (24*ScanPhaseShiftA + 18*ScanPhaseShiftB)
  1:980: ScanMag1*1 ScanPhase1 + (24*ScanPhaseShiftA + 19*ScanPhaseShiftB)
  1:981: ScanMag1*1 ScanPhase1 + (24*ScanPhaseShiftA + 20*ScanPhaseShiftB)
  1:982: ScanMag1*1 ScanPhase1 + (24*ScanPhaseShiftA + 21*ScanPhaseShiftB)
  1:983: ScanMag1*1 ScanPhase1 + (24*ScanPhaseShiftA + 22*ScanPhaseShiftB)
  1:984: ScanMag1*1 ScanPhase1 + (24*ScanPhaseShiftA + 23*ScanPhaseShiftB)
  1:985: ScanMag1*1 ScanPhase1 + (24*ScanPhaseShiftA + 24*ScanPhaseShiftB)
  1:986: ScanMag1*1 ScanPhase1 + (24*ScanPhaseShiftA + 25*ScanPhaseShiftB)
  1:987: ScanMag1*1 ScanPhase1 + (24*ScanPhaseShiftA + 26*ScanPhaseShiftB)
  1:988: ScanMag1*1 ScanPhase1 + (24*ScanPhaseShiftA + 27*ScanPhaseShiftB)
  1:989: ScanMag1*1 ScanPhase1 + (24*ScanPhaseShiftA + 28*ScanPhaseShiftB)
  1:990: ScanMag1*1 ScanPhase1 + (24*ScanPhaseShiftA + 29*ScanPhaseShiftB)
  1:991: ScanMag1*1 ScanPhase1 + (24*ScanPhaseShiftA + 30*ScanPhaseShiftB)
  1:992: ScanMag1*1 ScanPhase1 + (24*ScanPhaseShiftA + 31*ScanPhaseShiftB)
  1:993: ScanMag1*1 ScanPhase1 + (24*ScanPhaseShiftA + 32*ScanPhaseShiftB)
  1:994: ScanMag1*1 ScanPhase1 + (24*ScanPhaseShiftA + 33*ScanPhaseShiftB)
  1:995: ScanMag1*1 ScanPhase1 + (24*ScanPhaseShiftA + 34*ScanPhaseShiftB)
  1:996: ScanMag1*1 ScanPhase1 + (24*ScanPhaseShiftA + 35*ScanPhaseShiftB)
  1:997: ScanMag1*1 ScanPhase1 + (24*ScanPhaseShiftA + 36*ScanPhaseShiftB)
  1:998: ScanMag1*1 ScanPhase1 + (24*ScanPhaseShiftA + 37*ScanPhaseShiftB)
  1:999: ScanMag1*1 ScanPhase1 + (24*ScanPhaseShiftA + 38*ScanPhaseShiftB)
  1:1000: ScanMag1*1 ScanPhase1 + (24*ScanPhaseShiftA + 39*ScanPhaseShiftB)
  1:1001: ScanMag1*1 ScanPhase1 + (25*ScanPhaseShiftA + 0*ScanPhaseShiftB)
  1:1002: ScanMag1*1 ScanPhase1 + (25*ScanPhaseShiftA + 1*ScanPhaseShiftB)
  1:1003: ScanMag1*1 ScanPhase1 + (25*ScanPhaseShiftA + 2*ScanPhaseShiftB)
  1:1004: ScanMag1*1 ScanPhase1 + (25*ScanPhaseShiftA + 3*ScanPhaseShiftB)
  1:1005: ScanMag1*1 ScanPhase1 + (25*ScanPhaseShiftA + 4*ScanPhaseShiftB)
  1:1006: ScanMag1*1 ScanPhase1 + (25*ScanPhaseShiftA + 5*ScanPhaseShiftB)
  1:1007: ScanMag1*1 ScanPhase1 + (25*ScanPhaseShiftA + 6*ScanPhaseShiftB)
  1:1008: ScanMag1*1 ScanPhase1 + (25*ScanPhaseShiftA + 7*ScanPhaseShiftB)
  1:1009: ScanMag1*1 ScanPhase1 + (25*ScanPhaseShiftA + 8*ScanPhaseShiftB)
  1:1010: ScanMag1*1 ScanPhase1 + (25*ScanPhaseShiftA + 9*ScanPhaseShiftB)
  1:1011: ScanMag1*1 ScanPhase1 + (25*ScanPhaseShiftA + 10*ScanPhaseShiftB)
  1:1012: ScanMag1*1 ScanPhase1 + (25*ScanPhaseShiftA + 11*ScanPhaseShiftB)
  1:1013: ScanMag1*1 ScanPhase1 + (25*ScanPhaseShiftA + 12*ScanPhaseShiftB)
  1:1014: ScanMag1*1 ScanPhase1 + (25*ScanPhaseShiftA + 13*ScanPhaseShiftB)
  1:1015: ScanMag1*1 ScanPhase1 + (25*ScanPhaseShiftA + 14*ScanPhaseShiftB)
  1:1016: ScanMag1*1 ScanPhase1 + (25*ScanPhaseShiftA + 15*ScanPhaseShiftB)
  1:1017: ScanMag1*1 ScanPhase1 + (25*ScanPhaseShiftA + 16*ScanPhaseShiftB)
  1:1018: ScanMag1*1 ScanPhase1 + (25*ScanPhaseShiftA + 17*ScanPhaseShiftB)
  1:1019: ScanMag1*1 ScanPhase1 + (25*ScanPhaseShiftA + 18*ScanPhaseShiftB)
  1:1020: ScanMag1*1 ScanPhase1 + (25*ScanPhaseShiftA + 19*ScanPhaseShiftB)
  1:1021: ScanMag1*1 ScanPhase1 + (25*ScanPhaseShiftA + 20*ScanPhaseShiftB)
  1:1022: ScanMag1*1 ScanPhase1 + (25*ScanPhaseShiftA + 21*ScanPhaseShiftB)
  1:1023: ScanMag1*1 ScanPhase1 + (25*ScanPhaseShiftA + 22*ScanPhaseShiftB)
  1:1024: ScanMag1*1 ScanPhase1 + (25*ScanPhaseShiftA + 23*ScanPhaseShiftB)
  1:1025: ScanMag1*1 ScanPhase1 + (25*ScanPhaseShiftA + 24*ScanPhaseShiftB)
  1:1026: ScanMag1*1 ScanPhase1 + (25*ScanPhaseShiftA + 25*ScanPhaseShiftB)
  1:1027: ScanMag1*1 ScanPhase1 + (25*ScanPhaseShiftA + 26*ScanPhaseShiftB)
  1:1028: ScanMag1*1 ScanPhase1 + (25*ScanPhaseShiftA + 27*ScanPhaseShiftB)
  1:1029: ScanMag1*1 ScanPhase1 + (25*ScanPhaseShiftA + 28*ScanPhaseShiftB)
  1:1030: ScanMag1*1 ScanPhase1 + (25*ScanPhaseShiftA + 29*ScanPhaseShiftB)
  1:1031: ScanMag1*1 ScanPhase1 + (25*ScanPhaseShiftA + 30*ScanPhaseShiftB)
  1:1032: ScanMag1*1 ScanPhase1 + (25*ScanPhaseShiftA + 31*ScanPhaseShiftB)
  1:1033: ScanMag1*1 ScanPhase1 + (25*ScanPhaseShiftA + 32*ScanPhaseShiftB)
  1:1034: ScanMag1*1 ScanPhase1 + (25*ScanPhaseShiftA + 33*ScanPhaseShiftB)
  1:1035: ScanMag1*1 ScanPhase1 + (25*ScanPhaseShiftA + 34*ScanPhaseShiftB)
  1:1036: ScanMag1*1 ScanPhase1 + (25*ScanPhaseShiftA + 35*ScanPhaseShiftB)
  1:1037: ScanMag1*1 ScanPhase1 + (25*ScanPhaseShiftA + 36*ScanPhaseShiftB)
  1:1038: ScanMag1*1 ScanPhase1 + (25*ScanPhaseShiftA + 37*ScanPhaseShiftB)
  1:1039: ScanMag1*1 ScanPhase1 + (25*ScanPhaseShiftA + 38*ScanPhaseShiftB)
  1:1040: ScanMag1*1 ScanPhase1 + (25*ScanPhaseShiftA + 39*ScanPhaseShiftB)
  1:1041: ScanMag1*1 ScanPhase1 + (26*ScanPhaseShiftA + 0*ScanPhaseShiftB)
  1:1042: ScanMag1*1 ScanPhase1 + (26*ScanPhaseShiftA + 1*ScanPhaseShiftB)
  1:1043: ScanMag1*1 ScanPhase1 + (26*ScanPhaseShiftA + 2*ScanPhaseShiftB)
  1:1044: ScanMag1*1 ScanPhase1 + (26*ScanPhaseShiftA + 3*ScanPhaseShiftB)
  1:1045: ScanMag1*1 ScanPhase1 + (26*ScanPhaseShiftA + 4*ScanPhaseShiftB)
  1:1046: ScanMag1*1 ScanPhase1 + (26*ScanPhaseShiftA + 5*ScanPhaseShiftB)
  1:1047: ScanMag1*1 ScanPhase1 + (26*ScanPhaseShiftA + 6*ScanPhaseShiftB)
  1:1048: ScanMag1*1 ScanPhase1 + (26*ScanPhaseShiftA + 7*ScanPhaseShiftB)
  1:1049: ScanMag1*1 ScanPhase1 + (26*ScanPhaseShiftA + 8*ScanPhaseShiftB)
  1:1050: ScanMag1*1 ScanPhase1 + (26*ScanPhaseShiftA + 9*ScanPhaseShiftB)
  1:1051: ScanMag1*1 ScanPhase1 + (26*ScanPhaseShiftA + 10*ScanPhaseShiftB)
  1:1052: ScanMag1*1 ScanPhase1 + (26*ScanPhaseShiftA + 11*ScanPhaseShiftB)
  1:1053: ScanMag1*1 ScanPhase1 + (26*ScanPhaseShiftA + 12*ScanPhaseShiftB)
  1:1054: ScanMag1*1 ScanPhase1 + (26*ScanPhaseShiftA + 13*ScanPhaseShiftB)
  1:1055: ScanMag1*1 ScanPhase1 + (26*ScanPhaseShiftA + 14*ScanPhaseShiftB)
  1:1056: ScanMag1*1 ScanPhase1 + (26*ScanPhaseShiftA + 15*ScanPhaseShiftB)
  1:1057: ScanMag1*1 ScanPhase1 + (26*ScanPhaseShiftA + 16*ScanPhaseShiftB)
  1:1058: ScanMag1*1 ScanPhase1 + (26*ScanPhaseShiftA + 17*ScanPhaseShiftB)
  1:1059: ScanMag1*1 ScanPhase1 + (26*ScanPhaseShiftA + 18*ScanPhaseShiftB)
  1:1060: ScanMag1*1 ScanPhase1 + (26*ScanPhaseShiftA + 19*ScanPhaseShiftB)
  1:1061: ScanMag1*1 ScanPhase1 + (26*ScanPhaseShiftA + 20*ScanPhaseShiftB)
  1:1062: ScanMag1*1 ScanPhase1 + (26*ScanPhaseShiftA + 21*ScanPhaseShiftB)
  1:1063: ScanMag1*1 ScanPhase1 + (26*ScanPhaseShiftA + 22*ScanPhaseShiftB)
  1:1064: ScanMag1*1 ScanPhase1 + (26*ScanPhaseShiftA + 23*ScanPhaseShiftB)
  1:1065: ScanMag1*1 ScanPhase1 + (26*ScanPhaseShiftA + 24*ScanPhaseShiftB)
  1:1066: ScanMag1*1 ScanPhase1 + (26*ScanPhaseShiftA + 25*ScanPhaseShiftB)
  1:1067: ScanMag1*1 ScanPhase1 + (26*ScanPhaseShiftA + 26*ScanPhaseShiftB)
  1:1068: ScanMag1*1 ScanPhase1 + (26*ScanPhaseShiftA + 27*ScanPhaseShiftB)
  1:1069: ScanMag1*1 ScanPhase1 + (26*ScanPhaseShiftA + 28*ScanPhaseShiftB)
  1:1070: ScanMag1*1 ScanPhase1 + (26*ScanPhaseShiftA + 29*ScanPhaseShiftB)
  1:1071: ScanMag1*1 ScanPhase1 + (26*ScanPhaseShiftA + 30*ScanPhaseShiftB)
  1:1072: ScanMag1*1 ScanPhase1 + (26*ScanPhaseShiftA + 31*ScanPhaseShiftB)
  1:1073: ScanMag1*1 ScanPhase1 + (26*ScanPhaseShiftA + 32*ScanPhaseShiftB)
  1:1074: ScanMag1*1 ScanPhase1 + (26*ScanPhaseShiftA + 33*ScanPhaseShiftB)
  1:1075: ScanMag1*1 ScanPhase1 + (26*ScanPhaseShiftA + 34*ScanPhaseShiftB)
  1:1076: ScanMag1*1 ScanPhase1 + (26*ScanPhaseShiftA + 35*ScanPhaseShiftB)
  1:1077: ScanMag1*1 ScanPhase1 + (26*ScanPhaseShiftA + 36*ScanPhaseShiftB)
  1:1078: ScanMag1*1 ScanPhase1 + (26*ScanPhaseShiftA + 37*ScanPhaseShiftB)
  1:1079: ScanMag1*1 ScanPhase1 + (26*ScanPhaseShiftA + 38*ScanPhaseShiftB)
  1:1080: ScanMag1*1 ScanPhase1 + (26*ScanPhaseShiftA + 39*ScanPhaseShiftB)
  1:1081: ScanMag1*1 ScanPhase1 + (27*ScanPhaseShiftA + 0*ScanPhaseShiftB)
  1:1082: ScanMag1*1 ScanPhase1 + (27*ScanPhaseShiftA + 1*ScanPhaseShiftB)
  1:1083: ScanMag1*1 ScanPhase1 + (27*ScanPhaseShiftA + 2*ScanPhaseShiftB)
  1:1084: ScanMag1*1 ScanPhase1 + (27*ScanPhaseShiftA + 3*ScanPhaseShiftB)
  1:1085: ScanMag1*1 ScanPhase1 + (27*ScanPhaseShiftA + 4*ScanPhaseShiftB)
  1:1086: ScanMag1*1 ScanPhase1 + (27*ScanPhaseShiftA + 5*ScanPhaseShiftB)
  1:1087: ScanMag1*1 ScanPhase1 + (27*ScanPhaseShiftA + 6*ScanPhaseShiftB)
  1:1088: ScanMag1*1 ScanPhase1 + (27*ScanPhaseShiftA + 7*ScanPhaseShiftB)
  1:1089: ScanMag1*1 ScanPhase1 + (27*ScanPhaseShiftA + 8*ScanPhaseShiftB)
  1:1090: ScanMag1*1 ScanPhase1 + (27*ScanPhaseShiftA + 9*ScanPhaseShiftB)
  1:1091: ScanMag1*1 ScanPhase1 + (27*ScanPhaseShiftA + 10*ScanPhaseShiftB)
  1:1092: ScanMag1*1 ScanPhase1 + (27*ScanPhaseShiftA + 11*ScanPhaseShiftB)
  1:1093: ScanMag1*1 ScanPhase1 + (27*ScanPhaseShiftA + 12*ScanPhaseShiftB)
  1:1094: ScanMag1*1 ScanPhase1 + (27*ScanPhaseShiftA + 13*ScanPhaseShiftB)
  1:1095: ScanMag1*1 ScanPhase1 + (27*ScanPhaseShiftA + 14*ScanPhaseShiftB)
  1:1096: ScanMag1*1 ScanPhase1 + (27*ScanPhaseShiftA + 15*ScanPhaseShiftB)
  1:1097: ScanMag1*1 ScanPhase1 + (27*ScanPhaseShiftA + 16*ScanPhaseShiftB)
  1:1098: ScanMag1*1 ScanPhase1 + (27*ScanPhaseShiftA + 17*ScanPhaseShiftB)
  1:1099: ScanMag1*1 ScanPhase1 + (27*ScanPhaseShiftA + 18*ScanPhaseShiftB)
  1:1100: ScanMag1*1 ScanPhase1 + (27*ScanPhaseShiftA + 19*ScanPhaseShiftB)
  1:1101: ScanMag1*1 ScanPhase1 + (27*ScanPhaseShiftA + 20*ScanPhaseShiftB)
  1:1102: ScanMag1*1 ScanPhase1 + (27*ScanPhaseShiftA + 21*ScanPhaseShiftB)
  1:1103: ScanMag1*1 ScanPhase1 + (27*ScanPhaseShiftA + 22*ScanPhaseShiftB)
  1:1104: ScanMag1*1 ScanPhase1 + (27*ScanPhaseShiftA + 23*ScanPhaseShiftB)
  1:1105: ScanMag1*1 ScanPhase1 + (27*ScanPhaseShiftA + 24*ScanPhaseShiftB)
  1:1106: ScanMag1*1 ScanPhase1 + (27*ScanPhaseShiftA + 25*ScanPhaseShiftB)
  1:1107: ScanMag1*1 ScanPhase1 + (27*ScanPhaseShiftA + 26*ScanPhaseShiftB)
  1:1108: ScanMag1*1 ScanPhase1 + (27*ScanPhaseShiftA + 27*ScanPhaseShiftB)
  1:1109: ScanMag1*1 ScanPhase1 + (27*ScanPhaseShiftA + 28*ScanPhaseShiftB)
  1:1110: ScanMag1*1 ScanPhase1 + (27*ScanPhaseShiftA + 29*ScanPhaseShiftB)
  1:1111: ScanMag1*1 ScanPhase1 + (27*ScanPhaseShiftA + 30*ScanPhaseShiftB)
  1:1112: ScanMag1*1 ScanPhase1 + (27*ScanPhaseShiftA + 31*ScanPhaseShiftB)
  1:1113: ScanMag1*1 ScanPhase1 + (27*ScanPhaseShiftA + 32*ScanPhaseShiftB)
  1:1114: ScanMag1*1 ScanPhase1 + (27*ScanPhaseShiftA + 33*ScanPhaseShiftB)
  1:1115: ScanMag1*1 ScanPhase1 + (27*ScanPhaseShiftA + 34*ScanPhaseShiftB)
  1:1116: ScanMag1*1 ScanPhase1 + (27*ScanPhaseShiftA + 35*ScanPhaseShiftB)
  1:1117: ScanMag1*1 ScanPhase1 + (27*ScanPhaseShiftA + 36*ScanPhaseShiftB)
  1:1118: ScanMag1*1 ScanPhase1 + (27*ScanPhaseShiftA + 37*ScanPhaseShiftB)
  1:1119: ScanMag1*1 ScanPhase1 + (27*ScanPhaseShiftA + 38*ScanPhaseShiftB)
  1:1120: ScanMag1*1 ScanPhase1 + (27*ScanPhaseShiftA + 39*ScanPhaseShiftB)
  1:1121: ScanMag1*1 ScanPhase1 + (28*ScanPhaseShiftA + 0*ScanPhaseShiftB)
  1:1122: ScanMag1*1 ScanPhase1 + (28*ScanPhaseShiftA + 1*ScanPhaseShiftB)
  1:1123: ScanMag1*1 ScanPhase1 + (28*ScanPhaseShiftA + 2*ScanPhaseShiftB)
  1:1124: ScanMag1*1 ScanPhase1 + (28*ScanPhaseShiftA + 3*ScanPhaseShiftB)
  1:1125: ScanMag1*1 ScanPhase1 + (28*ScanPhaseShiftA + 4*ScanPhaseShiftB)
  1:1126: ScanMag1*1 ScanPhase1 + (28*ScanPhaseShiftA + 5*ScanPhaseShiftB)
  1:1127: ScanMag1*1 ScanPhase1 + (28*ScanPhaseShiftA + 6*ScanPhaseShiftB)
  1:1128: ScanMag1*1 ScanPhase1 + (28*ScanPhaseShiftA + 7*ScanPhaseShiftB)
  1:1129: ScanMag1*1 ScanPhase1 + (28*ScanPhaseShiftA + 8*ScanPhaseShiftB)
  1:1130: ScanMag1*1 ScanPhase1 + (28*ScanPhaseShiftA + 9*ScanPhaseShiftB)
  1:1131: ScanMag1*1 ScanPhase1 + (28*ScanPhaseShiftA + 10*ScanPhaseShiftB)
  1:1132: ScanMag1*1 ScanPhase1 + (28*ScanPhaseShiftA + 11*ScanPhaseShiftB)
  1:1133: ScanMag1*1 ScanPhase1 + (28*ScanPhaseShiftA + 12*ScanPhaseShiftB)
  1:1134: ScanMag1*1 ScanPhase1 + (28*ScanPhaseShiftA + 13*ScanPhaseShiftB)
  1:1135: ScanMag1*1 ScanPhase1 + (28*ScanPhaseShiftA + 14*ScanPhaseShiftB)
  1:1136: ScanMag1*1 ScanPhase1 + (28*ScanPhaseShiftA + 15*ScanPhaseShiftB)
  1:1137: ScanMag1*1 ScanPhase1 + (28*ScanPhaseShiftA + 16*ScanPhaseShiftB)
  1:1138: ScanMag1*1 ScanPhase1 + (28*ScanPhaseShiftA + 17*ScanPhaseShiftB)
  1:1139: ScanMag1*1 ScanPhase1 + (28*ScanPhaseShiftA + 18*ScanPhaseShiftB)
  1:1140: ScanMag1*1 ScanPhase1 + (28*ScanPhaseShiftA + 19*ScanPhaseShiftB)
  1:1141: ScanMag1*1 ScanPhase1 + (28*ScanPhaseShiftA + 20*ScanPhaseShiftB)
  1:1142: ScanMag1*1 ScanPhase1 + (28*ScanPhaseShiftA + 21*ScanPhaseShiftB)
  1:1143: ScanMag1*1 ScanPhase1 + (28*ScanPhaseShiftA + 22*ScanPhaseShiftB)
  1:1144: ScanMag1*1 ScanPhase1 + (28*ScanPhaseShiftA + 23*ScanPhaseShiftB)
  1:1145: ScanMag1*1 ScanPhase1 + (28*ScanPhaseShiftA + 24*ScanPhaseShiftB)
  1:1146: ScanMag1*1 ScanPhase1 + (28*ScanPhaseShiftA + 25*ScanPhaseShiftB)
  1:1147: ScanMag1*1 ScanPhase1 + (28*ScanPhaseShiftA + 26*ScanPhaseShiftB)
  1:1148: ScanMag1*1 ScanPhase1 + (28*ScanPhaseShiftA + 27*ScanPhaseShiftB)
  1:1149: ScanMag1*1 ScanPhase1 + (28*ScanPhaseShiftA + 28*ScanPhaseShiftB)
  1:1150: ScanMag1*1 ScanPhase1 + (28*ScanPhaseShiftA + 29*ScanPhaseShiftB)
  1:1151: ScanMag1*1 ScanPhase1 + (28*ScanPhaseShiftA + 30*ScanPhaseShiftB)
  1:1152: ScanMag1*1 ScanPhase1 + (28*ScanPhaseShiftA + 31*ScanPhaseShiftB)
  1:1153: ScanMag1*1 ScanPhase1 + (28*ScanPhaseShiftA + 32*ScanPhaseShiftB)
  1:1154: ScanMag1*1 ScanPhase1 + (28*ScanPhaseShiftA + 33*ScanPhaseShiftB)
  1:1155: ScanMag1*1 ScanPhase1 + (28*ScanPhaseShiftA + 34*ScanPhaseShiftB)
  1:1156: ScanMag1*1 ScanPhase1 + (28*ScanPhaseShiftA + 35*ScanPhaseShiftB)
  1:1157: ScanMag1*1 ScanPhase1 + (28*ScanPhaseShiftA + 36*ScanPhaseShiftB)
  1:1158: ScanMag1*1 ScanPhase1 + (28*ScanPhaseShiftA + 37*ScanPhaseShiftB)
  1:1159: ScanMag1*1 ScanPhase1 + (28*ScanPhaseShiftA + 38*ScanPhaseShiftB)
  1:1160: ScanMag1*1 ScanPhase1 + (28*ScanPhaseShiftA + 39*ScanPhaseShiftB)
  1:1161: ScanMag1*1 ScanPhase1 + (29*ScanPhaseShiftA + 0*ScanPhaseShiftB)
  1:1162: ScanMag1*1 ScanPhase1 + (29*ScanPhaseShiftA + 1*ScanPhaseShiftB)
  1:1163: ScanMag1*1 ScanPhase1 + (29*ScanPhaseShiftA + 2*ScanPhaseShiftB)
  1:1164: ScanMag1*1 ScanPhase1 + (29*ScanPhaseShiftA + 3*ScanPhaseShiftB)
  1:1165: ScanMag1*1 ScanPhase1 + (29*ScanPhaseShiftA + 4*ScanPhaseShiftB)
  1:1166: ScanMag1*1 ScanPhase1 + (29*ScanPhaseShiftA + 5*ScanPhaseShiftB)
  1:1167: ScanMag1*1 ScanPhase1 + (29*ScanPhaseShiftA + 6*ScanPhaseShiftB)
  1:1168: ScanMag1*1 ScanPhase1 + (29*ScanPhaseShiftA + 7*ScanPhaseShiftB)
  1:1169: ScanMag1*1 ScanPhase1 + (29*ScanPhaseShiftA + 8*ScanPhaseShiftB)
  1:1170: ScanMag1*1 ScanPhase1 + (29*ScanPhaseShiftA + 9*ScanPhaseShiftB)
  1:1171: ScanMag1*1 ScanPhase1 + (29*ScanPhaseShiftA + 10*ScanPhaseShiftB)
  1:1172: ScanMag1*1 ScanPhase1 + (29*ScanPhaseShiftA + 11*ScanPhaseShiftB)
  1:1173: ScanMag1*1 ScanPhase1 + (29*ScanPhaseShiftA + 12*ScanPhaseShiftB)
  1:1174: ScanMag1*1 ScanPhase1 + (29*ScanPhaseShiftA + 13*ScanPhaseShiftB)
  1:1175: ScanMag1*1 ScanPhase1 + (29*ScanPhaseShiftA + 14*ScanPhaseShiftB)
  1:1176: ScanMag1*1 ScanPhase1 + (29*ScanPhaseShiftA + 15*ScanPhaseShiftB)
  1:1177: ScanMag1*1 ScanPhase1 + (29*ScanPhaseShiftA + 16*ScanPhaseShiftB)
  1:1178: ScanMag1*1 ScanPhase1 + (29*ScanPhaseShiftA + 17*ScanPhaseShiftB)
  1:1179: ScanMag1*1 ScanPhase1 + (29*ScanPhaseShiftA + 18*ScanPhaseShiftB)
  1:1180: ScanMag1*1 ScanPhase1 + (29*ScanPhaseShiftA + 19*ScanPhaseShiftB)
  1:1181: ScanMag1*1 ScanPhase1 + (29*ScanPhaseShiftA + 20*ScanPhaseShiftB)
  1:1182: ScanMag1*1 ScanPhase1 + (29*ScanPhaseShiftA + 21*ScanPhaseShiftB)
  1:1183: ScanMag1*1 ScanPhase1 + (29*ScanPhaseShiftA + 22*ScanPhaseShiftB)
  1:1184: ScanMag1*1 ScanPhase1 + (29*ScanPhaseShiftA + 23*ScanPhaseShiftB)
  1:1185: ScanMag1*1 ScanPhase1 + (29*ScanPhaseShiftA + 24*ScanPhaseShiftB)
  1:1186: ScanMag1*1 ScanPhase1 + (29*ScanPhaseShiftA + 25*ScanPhaseShiftB)
  1:1187: ScanMag1*1 ScanPhase1 + (29*ScanPhaseShiftA + 26*ScanPhaseShiftB)
  1:1188: ScanMag1*1 ScanPhase1 + (29*ScanPhaseShiftA + 27*ScanPhaseShiftB)
  1:1189: ScanMag1*1 ScanPhase1 + (29*ScanPhaseShiftA + 28*ScanPhaseShiftB)
  1:1190: ScanMag1*1 ScanPhase1 + (29*ScanPhaseShiftA + 29*ScanPhaseShiftB)
  1:1191: ScanMag1*1 ScanPhase1 + (29*ScanPhaseShiftA + 30*ScanPhaseShiftB)
  1:1192: ScanMag1*1 ScanPhase1 + (29*ScanPhaseShiftA + 31*ScanPhaseShiftB)
  1:1193: ScanMag1*1 ScanPhase1 + (29*ScanPhaseShiftA + 32*ScanPhaseShiftB)
  1:1194: ScanMag1*1 ScanPhase1 + (29*ScanPhaseShiftA + 33*ScanPhaseShiftB)
  1:1195: ScanMag1*1 ScanPhase1 + (29*ScanPhaseShiftA + 34*ScanPhaseShiftB)
  1:1196: ScanMag1*1 ScanPhase1 + (29*ScanPhaseShiftA + 35*ScanPhaseShiftB)
  1:1197: ScanMag1*1 ScanPhase1 + (29*ScanPhaseShiftA + 36*ScanPhaseShiftB)
  1:1198: ScanMag1*1 ScanPhase1 + (29*ScanPhaseShiftA + 37*ScanPhaseShiftB)
  1:1199: ScanMag1*1 ScanPhase1 + (29*ScanPhaseShiftA + 38*ScanPhaseShiftB)
  1:1200: ScanMag1*1 ScanPhase1 + (29*ScanPhaseShiftA + 39*ScanPhaseShiftB)
  1:1201: ScanMag1*1 ScanPhase1 + (30*ScanPhaseShiftA + 0*ScanPhaseShiftB)
  1:1202: ScanMag1*1 ScanPhase1 + (30*ScanPhaseShiftA + 1*ScanPhaseShiftB)
  1:1203: ScanMag1*1 ScanPhase1 + (30*ScanPhaseShiftA + 2*ScanPhaseShiftB)
  1:1204: ScanMag1*1 ScanPhase1 + (30*ScanPhaseShiftA + 3*ScanPhaseShiftB)
  1:1205: ScanMag1*1 ScanPhase1 + (30*ScanPhaseShiftA + 4*ScanPhaseShiftB)
  1:1206: ScanMag1*1 ScanPhase1 + (30*ScanPhaseShiftA + 5*ScanPhaseShiftB)
  1:1207: ScanMag1*1 ScanPhase1 + (30*ScanPhaseShiftA + 6*ScanPhaseShiftB)
  1:1208: ScanMag1*1 ScanPhase1 + (30*ScanPhaseShiftA + 7*ScanPhaseShiftB)
  1:1209: ScanMag1*1 ScanPhase1 + (30*ScanPhaseShiftA + 8*ScanPhaseShiftB)
  1:1210: ScanMag1*1 ScanPhase1 + (30*ScanPhaseShiftA + 9*ScanPhaseShiftB)
  1:1211: ScanMag1*1 ScanPhase1 + (30*ScanPhaseShiftA + 10*ScanPhaseShiftB)
  1:1212: ScanMag1*1 ScanPhase1 + (30*ScanPhaseShiftA + 11*ScanPhaseShiftB)
  1:1213: ScanMag1*1 ScanPhase1 + (30*ScanPhaseShiftA + 12*ScanPhaseShiftB)
  1:1214: ScanMag1*1 ScanPhase1 + (30*ScanPhaseShiftA + 13*ScanPhaseShiftB)
  1:1215: ScanMag1*1 ScanPhase1 + (30*ScanPhaseShiftA + 14*ScanPhaseShiftB)
  1:1216: ScanMag1*1 ScanPhase1 + (30*ScanPhaseShiftA + 15*ScanPhaseShiftB)
  1:1217: ScanMag1*1 ScanPhase1 + (30*ScanPhaseShiftA + 16*ScanPhaseShiftB)
  1:1218: ScanMag1*1 ScanPhase1 + (30*ScanPhaseShiftA + 17*ScanPhaseShiftB)
  1:1219: ScanMag1*1 ScanPhase1 + (30*ScanPhaseShiftA + 18*ScanPhaseShiftB)
  1:1220: ScanMag1*1 ScanPhase1 + (30*ScanPhaseShiftA + 19*ScanPhaseShiftB)
  1:1221: ScanMag1*1 ScanPhase1 + (30*ScanPhaseShiftA + 20*ScanPhaseShiftB)
  1:1222: ScanMag1*1 ScanPhase1 + (30*ScanPhaseShiftA + 21*ScanPhaseShiftB)
  1:1223: ScanMag1*1 ScanPhase1 + (30*ScanPhaseShiftA + 22*ScanPhaseShiftB)
  1:1224: ScanMag1*1 ScanPhase1 + (30*ScanPhaseShiftA + 23*ScanPhaseShiftB)
  1:1225: ScanMag1*1 ScanPhase1 + (30*ScanPhaseShiftA + 24*ScanPhaseShiftB)
  1:1226: ScanMag1*1 ScanPhase1 + (30*ScanPhaseShiftA + 25*ScanPhaseShiftB)
  1:1227: ScanMag1*1 ScanPhase1 + (30*ScanPhaseShiftA + 26*ScanPhaseShiftB)
  1:1228: ScanMag1*1 ScanPhase1 + (30*ScanPhaseShiftA + 27*ScanPhaseShiftB)
  1:1229: ScanMag1*1 ScanPhase1 + (30*ScanPhaseShiftA + 28*ScanPhaseShiftB)
  1:1230: ScanMag1*1 ScanPhase1 + (30*ScanPhaseShiftA + 29*ScanPhaseShiftB)
  1:1231: ScanMag1*1 ScanPhase1 + (30*ScanPhaseShiftA + 30*ScanPhaseShiftB)
  1:1232: ScanMag1*1 ScanPhase1 + (30*ScanPhaseShiftA + 31*ScanPhaseShiftB)
  1:1233: ScanMag1*1 ScanPhase1 + (30*ScanPhaseShiftA + 32*ScanPhaseShiftB)
  1:1234: ScanMag1*1 ScanPhase1 + (30*ScanPhaseShiftA + 33*ScanPhaseShiftB)
  1:1235: ScanMag1*1 ScanPhase1 + (30*ScanPhaseShiftA + 34*ScanPhaseShiftB)
  1:1236: ScanMag1*1 ScanPhase1 + (30*ScanPhaseShiftA + 35*ScanPhaseShiftB)
  1:1237: ScanMag1*1 ScanPhase1 + (30*ScanPhaseShiftA + 36*ScanPhaseShiftB)
  1:1238: ScanMag1*1 ScanPhase1 + (30*ScanPhaseShiftA + 37*ScanPhaseShiftB)
  1:1239: ScanMag1*1 ScanPhase1 + (30*ScanPhaseShiftA + 38*ScanPhaseShiftB)
  1:1240: ScanMag1*1 ScanPhase1 + (30*ScanPhaseShiftA + 39*ScanPhaseShiftB)
  1:1241: ScanMag1*1 ScanPhase1 + (31*ScanPhaseShiftA + 0*ScanPhaseShiftB)
  1:1242: ScanMag1*1 ScanPhase1 + (31*ScanPhaseShiftA + 1*ScanPhaseShiftB)
  1:1243: ScanMag1*1 ScanPhase1 + (31*ScanPhaseShiftA + 2*ScanPhaseShiftB)
  1:1244: ScanMag1*1 ScanPhase1 + (31*ScanPhaseShiftA + 3*ScanPhaseShiftB)
  1:1245: ScanMag1*1 ScanPhase1 + (31*ScanPhaseShiftA + 4*ScanPhaseShiftB)
  1:1246: ScanMag1*1 ScanPhase1 + (31*ScanPhaseShiftA + 5*ScanPhaseShiftB)
  1:1247: ScanMag1*1 ScanPhase1 + (31*ScanPhaseShiftA + 6*ScanPhaseShiftB)
  1:1248: ScanMag1*1 ScanPhase1 + (31*ScanPhaseShiftA + 7*ScanPhaseShiftB)
  1:1249: ScanMag1*1 ScanPhase1 + (31*ScanPhaseShiftA + 8*ScanPhaseShiftB)
  1:1250: ScanMag1*1 ScanPhase1 + (31*ScanPhaseShiftA + 9*ScanPhaseShiftB)
  1:1251: ScanMag1*1 ScanPhase1 + (31*ScanPhaseShiftA + 10*ScanPhaseShiftB)
  1:1252: ScanMag1*1 ScanPhase1 + (31*ScanPhaseShiftA + 11*ScanPhaseShiftB)
  1:1253: ScanMag1*1 ScanPhase1 + (31*ScanPhaseShiftA + 12*ScanPhaseShiftB)
  1:1254: ScanMag1*1 ScanPhase1 + (31*ScanPhaseShiftA + 13*ScanPhaseShiftB)
  1:1255: ScanMag1*1 ScanPhase1 + (31*ScanPhaseShiftA + 14*ScanPhaseShiftB)
  1:1256: ScanMag1*1 ScanPhase1 + (31*ScanPhaseShiftA + 15*ScanPhaseShiftB)
  1:1257: ScanMag1*1 ScanPhase1 + (31*ScanPhaseShiftA + 16*ScanPhaseShiftB)
  1:1258: ScanMag1*1 ScanPhase1 + (31*ScanPhaseShiftA + 17*ScanPhaseShiftB)
  1:1259: ScanMag1*1 ScanPhase1 + (31*ScanPhaseShiftA + 18*ScanPhaseShiftB)
  1:1260: ScanMag1*1 ScanPhase1 + (31*ScanPhaseShiftA + 19*ScanPhaseShiftB)
  1:1261: ScanMag1*1 ScanPhase1 + (31*ScanPhaseShiftA + 20*ScanPhaseShiftB)
  1:1262: ScanMag1*1 ScanPhase1 + (31*ScanPhaseShiftA + 21*ScanPhaseShiftB)
  1:1263: ScanMag1*1 ScanPhase1 + (31*ScanPhaseShiftA + 22*ScanPhaseShiftB)
  1:1264: ScanMag1*1 ScanPhase1 + (31*ScanPhaseShiftA + 23*ScanPhaseShiftB)
  1:1265: ScanMag1*1 ScanPhase1 + (31*ScanPhaseShiftA + 24*ScanPhaseShiftB)
  1:1266: ScanMag1*1 ScanPhase1 + (31*ScanPhaseShiftA + 25*ScanPhaseShiftB)
  1:1267: ScanMag1*1 ScanPhase1 + (31*ScanPhaseShiftA + 26*ScanPhaseShiftB)
  1:1268: ScanMag1*1 ScanPhase1 + (31*ScanPhaseShiftA + 27*ScanPhaseShiftB)
  1:1269: ScanMag1*1 ScanPhase1 + (31*ScanPhaseShiftA + 28*ScanPhaseShiftB)
  1:1270: ScanMag1*1 ScanPhase1 + (31*ScanPhaseShiftA + 29*ScanPhaseShiftB)
  1:1271: ScanMag1*1 ScanPhase1 + (31*ScanPhaseShiftA + 30*ScanPhaseShiftB)
  1:1272: ScanMag1*1 ScanPhase1 + (31*ScanPhaseShiftA + 31*ScanPhaseShiftB)
  1:1273: ScanMag1*1 ScanPhase1 + (31*ScanPhaseShiftA + 32*ScanPhaseShiftB)
  1:1274: ScanMag1*1 ScanPhase1 + (31*ScanPhaseShiftA + 33*ScanPhaseShiftB)
  1:1275: ScanMag1*1 ScanPhase1 + (31*ScanPhaseShiftA + 34*ScanPhaseShiftB)
  1:1276: ScanMag1*1 ScanPhase1 + (31*ScanPhaseShiftA + 35*ScanPhaseShiftB)
  1:1277: ScanMag1*1 ScanPhase1 + (31*ScanPhaseShiftA + 36*ScanPhaseShiftB)
  1:1278: ScanMag1*1 ScanPhase1 + (31*ScanPhaseShiftA + 37*ScanPhaseShiftB)
  1:1279: ScanMag1*1 ScanPhase1 + (31*ScanPhaseShiftA + 38*ScanPhaseShiftB)
  1:1280: ScanMag1*1 ScanPhase1 + (31*ScanPhaseShiftA + 39*ScanPhaseShiftB)
  1:1281: ScanMag1*1 ScanPhase1 + (32*ScanPhaseShiftA + 0*ScanPhaseShiftB)
  1:1282: ScanMag1*1 ScanPhase1 + (32*ScanPhaseShiftA + 1*ScanPhaseShiftB)
  1:1283: ScanMag1*1 ScanPhase1 + (32*ScanPhaseShiftA + 2*ScanPhaseShiftB)
  1:1284: ScanMag1*1 ScanPhase1 + (32*ScanPhaseShiftA + 3*ScanPhaseShiftB)
  1:1285: ScanMag1*1 ScanPhase1 + (32*ScanPhaseShiftA + 4*ScanPhaseShiftB)
  1:1286: ScanMag1*1 ScanPhase1 + (32*ScanPhaseShiftA + 5*ScanPhaseShiftB)
  1:1287: ScanMag1*1 ScanPhase1 + (32*ScanPhaseShiftA + 6*ScanPhaseShiftB)
  1:1288: ScanMag1*1 ScanPhase1 + (32*ScanPhaseShiftA + 7*ScanPhaseShiftB)
  1:1289: ScanMag1*1 ScanPhase1 + (32*ScanPhaseShiftA + 8*ScanPhaseShiftB)
  1:1290: ScanMag1*1 ScanPhase1 + (32*ScanPhaseShiftA + 9*ScanPhaseShiftB)
  1:1291: ScanMag1*1 ScanPhase1 + (32*ScanPhaseShiftA + 10*ScanPhaseShiftB)
  1:1292: ScanMag1*1 ScanPhase1 + (32*ScanPhaseShiftA + 11*ScanPhaseShiftB)
  1:1293: ScanMag1*1 ScanPhase1 + (32*ScanPhaseShiftA + 12*ScanPhaseShiftB)
  1:1294: ScanMag1*1 ScanPhase1 + (32*ScanPhaseShiftA + 13*ScanPhaseShiftB)
  1:1295: ScanMag1*1 ScanPhase1 + (32*ScanPhaseShiftA + 14*ScanPhaseShiftB)
  1:1296: ScanMag1*1 ScanPhase1 + (32*ScanPhaseShiftA + 15*ScanPhaseShiftB)
  1:1297: ScanMag1*1 ScanPhase1 + (32*ScanPhaseShiftA + 16*ScanPhaseShiftB)
  1:1298: ScanMag1*1 ScanPhase1 + (32*ScanPhaseShiftA + 17*ScanPhaseShiftB)
  1:1299: ScanMag1*1 ScanPhase1 + (32*ScanPhaseShiftA + 18*ScanPhaseShiftB)
  1:1300: ScanMag1*1 ScanPhase1 + (32*ScanPhaseShiftA + 19*ScanPhaseShiftB)
  1:1301: ScanMag1*1 ScanPhase1 + (32*ScanPhaseShiftA + 20*ScanPhaseShiftB)
  1:1302: ScanMag1*1 ScanPhase1 + (32*ScanPhaseShiftA + 21*ScanPhaseShiftB)
  1:1303: ScanMag1*1 ScanPhase1 + (32*ScanPhaseShiftA + 22*ScanPhaseShiftB)
  1:1304: ScanMag1*1 ScanPhase1 + (32*ScanPhaseShiftA + 23*ScanPhaseShiftB)
  1:1305: ScanMag1*1 ScanPhase1 + (32*ScanPhaseShiftA + 24*ScanPhaseShiftB)
  1:1306: ScanMag1*1 ScanPhase1 + (32*ScanPhaseShiftA + 25*ScanPhaseShiftB)
  1:1307: ScanMag1*1 ScanPhase1 + (32*ScanPhaseShiftA + 26*ScanPhaseShiftB)
  1:1308: ScanMag1*1 ScanPhase1 + (32*ScanPhaseShiftA + 27*ScanPhaseShiftB)
  1:1309: ScanMag1*1 ScanPhase1 + (32*ScanPhaseShiftA + 28*ScanPhaseShiftB)
  1:1310: ScanMag1*1 ScanPhase1 + (32*ScanPhaseShiftA + 29*ScanPhaseShiftB)
  1:1311: ScanMag1*1 ScanPhase1 + (32*ScanPhaseShiftA + 30*ScanPhaseShiftB)
  1:1312: ScanMag1*1 ScanPhase1 + (32*ScanPhaseShiftA + 31*ScanPhaseShiftB)
  1:1313: ScanMag1*1 ScanPhase1 + (32*ScanPhaseShiftA + 32*ScanPhaseShiftB)
  1:1314: ScanMag1*1 ScanPhase1 + (32*ScanPhaseShiftA + 33*ScanPhaseShiftB)
  1:1315: ScanMag1*1 ScanPhase1 + (32*ScanPhaseShiftA + 34*ScanPhaseShiftB)
  1:1316: ScanMag1*1 ScanPhase1 + (32*ScanPhaseShiftA + 35*ScanPhaseShiftB)
  1:1317: ScanMag1*1 ScanPhase1 + (32*ScanPhaseShiftA + 36*ScanPhaseShiftB)
  1:1318: ScanMag1*1 ScanPhase1 + (32*ScanPhaseShiftA + 37*ScanPhaseShiftB)
  1:1319: ScanMag1*1 ScanPhase1 + (32*ScanPhaseShiftA + 38*ScanPhaseShiftB)
  1:1320: ScanMag1*1 ScanPhase1 + (32*ScanPhaseShiftA + 39*ScanPhaseShiftB)
  1:1321: ScanMag1*1 ScanPhase1 + (33*ScanPhaseShiftA + 0*ScanPhaseShiftB)
  1:1322: ScanMag1*1 ScanPhase1 + (33*ScanPhaseShiftA + 1*ScanPhaseShiftB)
  1:1323: ScanMag1*1 ScanPhase1 + (33*ScanPhaseShiftA + 2*ScanPhaseShiftB)
  1:1324: ScanMag1*1 ScanPhase1 + (33*ScanPhaseShiftA + 3*ScanPhaseShiftB)
  1:1325: ScanMag1*1 ScanPhase1 + (33*ScanPhaseShiftA + 4*ScanPhaseShiftB)
  1:1326: ScanMag1*1 ScanPhase1 + (33*ScanPhaseShiftA + 5*ScanPhaseShiftB)
  1:1327: ScanMag1*1 ScanPhase1 + (33*ScanPhaseShiftA + 6*ScanPhaseShiftB)
  1:1328: ScanMag1*1 ScanPhase1 + (33*ScanPhaseShiftA + 7*ScanPhaseShiftB)
  1:1329: ScanMag1*1 ScanPhase1 + (33*ScanPhaseShiftA + 8*ScanPhaseShiftB)
  1:1330: ScanMag1*1 ScanPhase1 + (33*ScanPhaseShiftA + 9*ScanPhaseShiftB)
  1:1331: ScanMag1*1 ScanPhase1 + (33*ScanPhaseShiftA + 10*ScanPhaseShiftB)
  1:1332: ScanMag1*1 ScanPhase1 + (33*ScanPhaseShiftA + 11*ScanPhaseShiftB)
  1:1333: ScanMag1*1 ScanPhase1 + (33*ScanPhaseShiftA + 12*ScanPhaseShiftB)
  1:1334: ScanMag1*1 ScanPhase1 + (33*ScanPhaseShiftA + 13*ScanPhaseShiftB)
  1:1335: ScanMag1*1 ScanPhase1 + (33*ScanPhaseShiftA + 14*ScanPhaseShiftB)
  1:1336: ScanMag1*1 ScanPhase1 + (33*ScanPhaseShiftA + 15*ScanPhaseShiftB)
  1:1337: ScanMag1*1 ScanPhase1 + (33*ScanPhaseShiftA + 16*ScanPhaseShiftB)
  1:1338: ScanMag1*1 ScanPhase1 + (33*ScanPhaseShiftA + 17*ScanPhaseShiftB)
  1:1339: ScanMag1*1 ScanPhase1 + (33*ScanPhaseShiftA + 18*ScanPhaseShiftB)
  1:1340: ScanMag1*1 ScanPhase1 + (33*ScanPhaseShiftA + 19*ScanPhaseShiftB)
  1:1341: ScanMag1*1 ScanPhase1 + (33*ScanPhaseShiftA + 20*ScanPhaseShiftB)
  1:1342: ScanMag1*1 ScanPhase1 + (33*ScanPhaseShiftA + 21*ScanPhaseShiftB)
  1:1343: ScanMag1*1 ScanPhase1 + (33*ScanPhaseShiftA + 22*ScanPhaseShiftB)
  1:1344: ScanMag1*1 ScanPhase1 + (33*ScanPhaseShiftA + 23*ScanPhaseShiftB)
  1:1345: ScanMag1*1 ScanPhase1 + (33*ScanPhaseShiftA + 24*ScanPhaseShiftB)
  1:1346: ScanMag1*1 ScanPhase1 + (33*ScanPhaseShiftA + 25*ScanPhaseShiftB)
  1:1347: ScanMag1*1 ScanPhase1 + (33*ScanPhaseShiftA + 26*ScanPhaseShiftB)
  1:1348: ScanMag1*1 ScanPhase1 + (33*ScanPhaseShiftA + 27*ScanPhaseShiftB)
  1:1349: ScanMag1*1 ScanPhase1 + (33*ScanPhaseShiftA + 28*ScanPhaseShiftB)
  1:1350: ScanMag1*1 ScanPhase1 + (33*ScanPhaseShiftA + 29*ScanPhaseShiftB)
  1:1351: ScanMag1*1 ScanPhase1 + (33*ScanPhaseShiftA + 30*ScanPhaseShiftB)
  1:1352: ScanMag1*1 ScanPhase1 + (33*ScanPhaseShiftA + 31*ScanPhaseShiftB)
  1:1353: ScanMag1*1 ScanPhase1 + (33*ScanPhaseShiftA + 32*ScanPhaseShiftB)
  1:1354: ScanMag1*1 ScanPhase1 + (33*ScanPhaseShiftA + 33*ScanPhaseShiftB)
  1:1355: ScanMag1*1 ScanPhase1 + (33*ScanPhaseShiftA + 34*ScanPhaseShiftB)
  1:1356: ScanMag1*1 ScanPhase1 + (33*ScanPhaseShiftA + 35*ScanPhaseShiftB)
  1:1357: ScanMag1*1 ScanPhase1 + (33*ScanPhaseShiftA + 36*ScanPhaseShiftB)
  1:1358: ScanMag1*1 ScanPhase1 + (33*ScanPhaseShiftA + 37*ScanPhaseShiftB)
  1:1359: ScanMag1*1 ScanPhase1 + (33*ScanPhaseShiftA + 38*ScanPhaseShiftB)
  1:1360: ScanMag1*1 ScanPhase1 + (33*ScanPhaseShiftA + 39*ScanPhaseShiftB)
  1:1361: ScanMag1*1 ScanPhase1 + (34*ScanPhaseShiftA + 0*ScanPhaseShiftB)
  1:1362: ScanMag1*1 ScanPhase1 + (34*ScanPhaseShiftA + 1*ScanPhaseShiftB)
  1:1363: ScanMag1*1 ScanPhase1 + (34*ScanPhaseShiftA + 2*ScanPhaseShiftB)
  1:1364: ScanMag1*1 ScanPhase1 + (34*ScanPhaseShiftA + 3*ScanPhaseShiftB)
  1:1365: ScanMag1*1 ScanPhase1 + (34*ScanPhaseShiftA + 4*ScanPhaseShiftB)
  1:1366: ScanMag1*1 ScanPhase1 + (34*ScanPhaseShiftA + 5*ScanPhaseShiftB)
  1:1367: ScanMag1*1 ScanPhase1 + (34*ScanPhaseShiftA + 6*ScanPhaseShiftB)
  1:1368: ScanMag1*1 ScanPhase1 + (34*ScanPhaseShiftA + 7*ScanPhaseShiftB)
  1:1369: ScanMag1*1 ScanPhase1 + (34*ScanPhaseShiftA + 8*ScanPhaseShiftB)
  1:1370: ScanMag1*1 ScanPhase1 + (34*ScanPhaseShiftA + 9*ScanPhaseShiftB)
  1:1371: ScanMag1*1 ScanPhase1 + (34*ScanPhaseShiftA + 10*ScanPhaseShiftB)
  1:1372: ScanMag1*1 ScanPhase1 + (34*ScanPhaseShiftA + 11*ScanPhaseShiftB)
  1:1373: ScanMag1*1 ScanPhase1 + (34*ScanPhaseShiftA + 12*ScanPhaseShiftB)
  1:1374: ScanMag1*1 ScanPhase1 + (34*ScanPhaseShiftA + 13*ScanPhaseShiftB)
  1:1375: ScanMag1*1 ScanPhase1 + (34*ScanPhaseShiftA + 14*ScanPhaseShiftB)
  1:1376: ScanMag1*1 ScanPhase1 + (34*ScanPhaseShiftA + 15*ScanPhaseShiftB)
  1:1377: ScanMag1*1 ScanPhase1 + (34*ScanPhaseShiftA + 16*ScanPhaseShiftB)
  1:1378: ScanMag1*1 ScanPhase1 + (34*ScanPhaseShiftA + 17*ScanPhaseShiftB)
  1:1379: ScanMag1*1 ScanPhase1 + (34*ScanPhaseShiftA + 18*ScanPhaseShiftB)
  1:1380: ScanMag1*1 ScanPhase1 + (34*ScanPhaseShiftA + 19*ScanPhaseShiftB)
  1:1381: ScanMag1*1 ScanPhase1 + (34*ScanPhaseShiftA + 20*ScanPhaseShiftB)
  1:1382: ScanMag1*1 ScanPhase1 + (34*ScanPhaseShiftA + 21*ScanPhaseShiftB)
  1:1383: ScanMag1*1 ScanPhase1 + (34*ScanPhaseShiftA + 22*ScanPhaseShiftB)
  1:1384: ScanMag1*1 ScanPhase1 + (34*ScanPhaseShiftA + 23*ScanPhaseShiftB)
  1:1385: ScanMag1*1 ScanPhase1 + (34*ScanPhaseShiftA + 24*ScanPhaseShiftB)
  1:1386: ScanMag1*1 ScanPhase1 + (34*ScanPhaseShiftA + 25*ScanPhaseShiftB)
  1:1387: ScanMag1*1 ScanPhase1 + (34*ScanPhaseShiftA + 26*ScanPhaseShiftB)
  1:1388: ScanMag1*1 ScanPhase1 + (34*ScanPhaseShiftA + 27*ScanPhaseShiftB)
  1:1389: ScanMag1*1 ScanPhase1 + (34*ScanPhaseShiftA + 28*ScanPhaseShiftB)
  1:1390: ScanMag1*1 ScanPhase1 + (34*ScanPhaseShiftA + 29*ScanPhaseShiftB)
  1:1391: ScanMag1*1 ScanPhase1 + (34*ScanPhaseShiftA + 30*ScanPhaseShiftB)
  1:1392: ScanMag1*1 ScanPhase1 + (34*ScanPhaseShiftA + 31*ScanPhaseShiftB)
  1:1393: ScanMag1*1 ScanPhase1 + (34*ScanPhaseShiftA + 32*ScanPhaseShiftB)
  1:1394: ScanMag1*1 ScanPhase1 + (34*ScanPhaseShiftA + 33*ScanPhaseShiftB)
  1:1395: ScanMag1*1 ScanPhase1 + (34*ScanPhaseShiftA + 34*ScanPhaseShiftB)
  1:1396: ScanMag1*1 ScanPhase1 + (34*ScanPhaseShiftA + 35*ScanPhaseShiftB)
  1:1397: ScanMag1*1 ScanPhase1 + (34*ScanPhaseShiftA + 36*ScanPhaseShiftB)
  1:1398: ScanMag1*1 ScanPhase1 + (34*ScanPhaseShiftA + 37*ScanPhaseShiftB)
  1:1399: ScanMag1*1 ScanPhase1 + (34*ScanPhaseShiftA + 38*ScanPhaseShiftB)
  1:1400: ScanMag1*1 ScanPhase1 + (34*ScanPhaseShiftA + 39*ScanPhaseShiftB)
  1:1401: ScanMag1*1 ScanPhase1 + (35*ScanPhaseShiftA + 0*ScanPhaseShiftB)
  1:1402: ScanMag1*1 ScanPhase1 + (35*ScanPhaseShiftA + 1*ScanPhaseShiftB)
  1:1403: ScanMag1*1 ScanPhase1 + (35*ScanPhaseShiftA + 2*ScanPhaseShiftB)
  1:1404: ScanMag1*1 ScanPhase1 + (35*ScanPhaseShiftA + 3*ScanPhaseShiftB)
  1:1405: ScanMag1*1 ScanPhase1 + (35*ScanPhaseShiftA + 4*ScanPhaseShiftB)
  1:1406: ScanMag1*1 ScanPhase1 + (35*ScanPhaseShiftA + 5*ScanPhaseShiftB)
  1:1407: ScanMag1*1 ScanPhase1 + (35*ScanPhaseShiftA + 6*ScanPhaseShiftB)
  1:1408: ScanMag1*1 ScanPhase1 + (35*ScanPhaseShiftA + 7*ScanPhaseShiftB)
  1:1409: ScanMag1*1 ScanPhase1 + (35*ScanPhaseShiftA + 8*ScanPhaseShiftB)
  1:1410: ScanMag1*1 ScanPhase1 + (35*ScanPhaseShiftA + 9*ScanPhaseShiftB)
  1:1411: ScanMag1*1 ScanPhase1 + (35*ScanPhaseShiftA + 10*ScanPhaseShiftB)
  1:1412: ScanMag1*1 ScanPhase1 + (35*ScanPhaseShiftA + 11*ScanPhaseShiftB)
  1:1413: ScanMag1*1 ScanPhase1 + (35*ScanPhaseShiftA + 12*ScanPhaseShiftB)
  1:1414: ScanMag1*1 ScanPhase1 + (35*ScanPhaseShiftA + 13*ScanPhaseShiftB)
  1:1415: ScanMag1*1 ScanPhase1 + (35*ScanPhaseShiftA + 14*ScanPhaseShiftB)
  1:1416: ScanMag1*1 ScanPhase1 + (35*ScanPhaseShiftA + 15*ScanPhaseShiftB)
  1:1417: ScanMag1*1 ScanPhase1 + (35*ScanPhaseShiftA + 16*ScanPhaseShiftB)
  1:1418: ScanMag1*1 ScanPhase1 + (35*ScanPhaseShiftA + 17*ScanPhaseShiftB)
  1:1419: ScanMag1*1 ScanPhase1 + (35*ScanPhaseShiftA + 18*ScanPhaseShiftB)
  1:1420: ScanMag1*1 ScanPhase1 + (35*ScanPhaseShiftA + 19*ScanPhaseShiftB)
  1:1421: ScanMag1*1 ScanPhase1 + (35*ScanPhaseShiftA + 20*ScanPhaseShiftB)
  1:1422: ScanMag1*1 ScanPhase1 + (35*ScanPhaseShiftA + 21*ScanPhaseShiftB)
  1:1423: ScanMag1*1 ScanPhase1 + (35*ScanPhaseShiftA + 22*ScanPhaseShiftB)
  1:1424: ScanMag1*1 ScanPhase1 + (35*ScanPhaseShiftA + 23*ScanPhaseShiftB)
  1:1425: ScanMag1*1 ScanPhase1 + (35*ScanPhaseShiftA + 24*ScanPhaseShiftB)
  1:1426: ScanMag1*1 ScanPhase1 + (35*ScanPhaseShiftA + 25*ScanPhaseShiftB)
  1:1427: ScanMag1*1 ScanPhase1 + (35*ScanPhaseShiftA + 26*ScanPhaseShiftB)
  1:1428: ScanMag1*1 ScanPhase1 + (35*ScanPhaseShiftA + 27*ScanPhaseShiftB)
  1:1429: ScanMag1*1 ScanPhase1 + (35*ScanPhaseShiftA + 28*ScanPhaseShiftB)
  1:1430: ScanMag1*1 ScanPhase1 + (35*ScanPhaseShiftA + 29*ScanPhaseShiftB)
  1:1431: ScanMag1*1 ScanPhase1 + (35*ScanPhaseShiftA + 30*ScanPhaseShiftB)
  1:1432: ScanMag1*1 ScanPhase1 + (35*ScanPhaseShiftA + 31*ScanPhaseShiftB)
  1:1433: ScanMag1*1 ScanPhase1 + (35*ScanPhaseShiftA + 32*ScanPhaseShiftB)
  1:1434: ScanMag1*1 ScanPhase1 + (35*ScanPhaseShiftA + 33*ScanPhaseShiftB)
  1:1435: ScanMag1*1 ScanPhase1 + (35*ScanPhaseShiftA + 34*ScanPhaseShiftB)
  1:1436: ScanMag1*1 ScanPhase1 + (35*ScanPhaseShiftA + 35*ScanPhaseShiftB)
  1:1437: ScanMag1*1 ScanPhase1 + (35*ScanPhaseShiftA + 36*ScanPhaseShiftB)
  1:1438: ScanMag1*1 ScanPhase1 + (35*ScanPhaseShiftA + 37*ScanPhaseShiftB)
  1:1439: ScanMag1*1 ScanPhase1 + (35*ScanPhaseShiftA + 38*ScanPhaseShiftB)
  1:1440: ScanMag1*1 ScanPhase1 + (35*ScanPhaseShiftA + 39*ScanPhaseShiftB)
  1:1441: ScanMag1*1 ScanPhase1 + (36*ScanPhaseShiftA + 0*ScanPhaseShiftB)
  1:1442: ScanMag1*1 ScanPhase1 + (36*ScanPhaseShiftA + 1*ScanPhaseShiftB)
  1:1443: ScanMag1*1 ScanPhase1 + (36*ScanPhaseShiftA + 2*ScanPhaseShiftB)
  1:1444: ScanMag1*1 ScanPhase1 + (36*ScanPhaseShiftA + 3*ScanPhaseShiftB)
  1:1445: ScanMag1*1 ScanPhase1 + (36*ScanPhaseShiftA + 4*ScanPhaseShiftB)
  1:1446: ScanMag1*1 ScanPhase1 + (36*ScanPhaseShiftA + 5*ScanPhaseShiftB)
  1:1447: ScanMag1*1 ScanPhase1 + (36*ScanPhaseShiftA + 6*ScanPhaseShiftB)
  1:1448: ScanMag1*1 ScanPhase1 + (36*ScanPhaseShiftA + 7*ScanPhaseShiftB)
  1:1449: ScanMag1*1 ScanPhase1 + (36*ScanPhaseShiftA + 8*ScanPhaseShiftB)
  1:1450: ScanMag1*1 ScanPhase1 + (36*ScanPhaseShiftA + 9*ScanPhaseShiftB)
  1:1451: ScanMag1*1 ScanPhase1 + (36*ScanPhaseShiftA + 10*ScanPhaseShiftB)
  1:1452: ScanMag1*1 ScanPhase1 + (36*ScanPhaseShiftA + 11*ScanPhaseShiftB)
  1:1453: ScanMag1*1 ScanPhase1 + (36*ScanPhaseShiftA + 12*ScanPhaseShiftB)
  1:1454: ScanMag1*1 ScanPhase1 + (36*ScanPhaseShiftA + 13*ScanPhaseShiftB)
  1:1455: ScanMag1*1 ScanPhase1 + (36*ScanPhaseShiftA + 14*ScanPhaseShiftB)
  1:1456: ScanMag1*1 ScanPhase1 + (36*ScanPhaseShiftA + 15*ScanPhaseShiftB)
  1:1457: ScanMag1*1 ScanPhase1 + (36*ScanPhaseShiftA + 16*ScanPhaseShiftB)
  1:1458: ScanMag1*1 ScanPhase1 + (36*ScanPhaseShiftA + 17*ScanPhaseShiftB)
  1:1459: ScanMag1*1 ScanPhase1 + (36*ScanPhaseShiftA + 18*ScanPhaseShiftB)
  1:1460: ScanMag1*1 ScanPhase1 + (36*ScanPhaseShiftA + 19*ScanPhaseShiftB)
  1:1461: ScanMag1*1 ScanPhase1 + (36*ScanPhaseShiftA + 20*ScanPhaseShiftB)
  1:1462: ScanMag1*1 ScanPhase1 + (36*ScanPhaseShiftA + 21*ScanPhaseShiftB)
  1:1463: ScanMag1*1 ScanPhase1 + (36*ScanPhaseShiftA + 22*ScanPhaseShiftB)
  1:1464: ScanMag1*1 ScanPhase1 + (36*ScanPhaseShiftA + 23*ScanPhaseShiftB)
  1:1465: ScanMag1*1 ScanPhase1 + (36*ScanPhaseShiftA + 24*ScanPhaseShiftB)
  1:1466: ScanMag1*1 ScanPhase1 + (36*ScanPhaseShiftA + 25*ScanPhaseShiftB)
  1:1467: ScanMag1*1 ScanPhase1 + (36*ScanPhaseShiftA + 26*ScanPhaseShiftB)
  1:1468: ScanMag1*1 ScanPhase1 + (36*ScanPhaseShiftA + 27*ScanPhaseShiftB)
  1:1469: ScanMag1*1 ScanPhase1 + (36*ScanPhaseShiftA + 28*ScanPhaseShiftB)
  1:1470: ScanMag1*1 ScanPhase1 + (36*ScanPhaseShiftA + 29*ScanPhaseShiftB)
  1:1471: ScanMag1*1 ScanPhase1 + (36*ScanPhaseShiftA + 30*ScanPhaseShiftB)
  1:1472: ScanMag1*1 ScanPhase1 + (36*ScanPhaseShiftA + 31*ScanPhaseShiftB)
  1:1473: ScanMag1*1 ScanPhase1 + (36*ScanPhaseShiftA + 32*ScanPhaseShiftB)
  1:1474: ScanMag1*1 ScanPhase1 + (36*ScanPhaseShiftA + 33*ScanPhaseShiftB)
  1:1475: ScanMag1*1 ScanPhase1 + (36*ScanPhaseShiftA + 34*ScanPhaseShiftB)
  1:1476: ScanMag1*1 ScanPhase1 + (36*ScanPhaseShiftA + 35*ScanPhaseShiftB)
  1:1477: ScanMag1*1 ScanPhase1 + (36*ScanPhaseShiftA + 36*ScanPhaseShiftB)
  1:1478: ScanMag1*1 ScanPhase1 + (36*ScanPhaseShiftA + 37*ScanPhaseShiftB)
  1:1479: ScanMag1*1 ScanPhase1 + (36*ScanPhaseShiftA + 38*ScanPhaseShiftB)
  1:1480: ScanMag1*1 ScanPhase1 + (36*ScanPhaseShiftA + 39*ScanPhaseShiftB)
  1:1481: ScanMag1*1 ScanPhase1 + (37*ScanPhaseShiftA + 0*ScanPhaseShiftB)
  1:1482: ScanMag1*1 ScanPhase1 + (37*ScanPhaseShiftA + 1*ScanPhaseShiftB)
  1:1483: ScanMag1*1 ScanPhase1 + (37*ScanPhaseShiftA + 2*ScanPhaseShiftB)
  1:1484: ScanMag1*1 ScanPhase1 + (37*ScanPhaseShiftA + 3*ScanPhaseShiftB)
  1:1485: ScanMag1*1 ScanPhase1 + (37*ScanPhaseShiftA + 4*ScanPhaseShiftB)
  1:1486: ScanMag1*1 ScanPhase1 + (37*ScanPhaseShiftA + 5*ScanPhaseShiftB)
  1:1487: ScanMag1*1 ScanPhase1 + (37*ScanPhaseShiftA + 6*ScanPhaseShiftB)
  1:1488: ScanMag1*1 ScanPhase1 + (37*ScanPhaseShiftA + 7*ScanPhaseShiftB)
  1:1489: ScanMag1*1 ScanPhase1 + (37*ScanPhaseShiftA + 8*ScanPhaseShiftB)
  1:1490: ScanMag1*1 ScanPhase1 + (37*ScanPhaseShiftA + 9*ScanPhaseShiftB)
  1:1491: ScanMag1*1 ScanPhase1 + (37*ScanPhaseShiftA + 10*ScanPhaseShiftB)
  1:1492: ScanMag1*1 ScanPhase1 + (37*ScanPhaseShiftA + 11*ScanPhaseShiftB)
  1:1493: ScanMag1*1 ScanPhase1 + (37*ScanPhaseShiftA + 12*ScanPhaseShiftB)
  1:1494: ScanMag1*1 ScanPhase1 + (37*ScanPhaseShiftA + 13*ScanPhaseShiftB)
  1:1495: ScanMag1*1 ScanPhase1 + (37*ScanPhaseShiftA + 14*ScanPhaseShiftB)
  1:1496: ScanMag1*1 ScanPhase1 + (37*ScanPhaseShiftA + 15*ScanPhaseShiftB)
  1:1497: ScanMag1*1 ScanPhase1 + (37*ScanPhaseShiftA + 16*ScanPhaseShiftB)
  1:1498: ScanMag1*1 ScanPhase1 + (37*ScanPhaseShiftA + 17*ScanPhaseShiftB)
  1:1499: ScanMag1*1 ScanPhase1 + (37*ScanPhaseShiftA + 18*ScanPhaseShiftB)
  1:1500: ScanMag1*1 ScanPhase1 + (37*ScanPhaseShiftA + 19*ScanPhaseShiftB)
  1:1501: ScanMag1*1 ScanPhase1 + (37*ScanPhaseShiftA + 20*ScanPhaseShiftB)
  1:1502: ScanMag1*1 ScanPhase1 + (37*ScanPhaseShiftA + 21*ScanPhaseShiftB)
  1:1503: ScanMag1*1 ScanPhase1 + (37*ScanPhaseShiftA + 22*ScanPhaseShiftB)
  1:1504: ScanMag1*1 ScanPhase1 + (37*ScanPhaseShiftA + 23*ScanPhaseShiftB)
  1:1505: ScanMag1*1 ScanPhase1 + (37*ScanPhaseShiftA + 24*ScanPhaseShiftB)
  1:1506: ScanMag1*1 ScanPhase1 + (37*ScanPhaseShiftA + 25*ScanPhaseShiftB)
  1:1507: ScanMag1*1 ScanPhase1 + (37*ScanPhaseShiftA + 26*ScanPhaseShiftB)
  1:1508: ScanMag1*1 ScanPhase1 + (37*ScanPhaseShiftA + 27*ScanPhaseShiftB)
  1:1509: ScanMag1*1 ScanPhase1 + (37*ScanPhaseShiftA + 28*ScanPhaseShiftB)
  1:1510: ScanMag1*1 ScanPhase1 + (37*ScanPhaseShiftA + 29*ScanPhaseShiftB)
  1:1511: ScanMag1*1 ScanPhase1 + (37*ScanPhaseShiftA + 30*ScanPhaseShiftB)
  1:1512: ScanMag1*1 ScanPhase1 + (37*ScanPhaseShiftA + 31*ScanPhaseShiftB)
  1:1513: ScanMag1*1 ScanPhase1 + (37*ScanPhaseShiftA + 32*ScanPhaseShiftB)
  1:1514: ScanMag1*1 ScanPhase1 + (37*ScanPhaseShiftA + 33*ScanPhaseShiftB)
  1:1515: ScanMag1*1 ScanPhase1 + (37*ScanPhaseShiftA + 34*ScanPhaseShiftB)
  1:1516: ScanMag1*1 ScanPhase1 + (37*ScanPhaseShiftA + 35*ScanPhaseShiftB)
  1:1517: ScanMag1*1 ScanPhase1 + (37*ScanPhaseShiftA + 36*ScanPhaseShiftB)
  1:1518: ScanMag1*1 ScanPhase1 + (37*ScanPhaseShiftA + 37*ScanPhaseShiftB)
  1:1519: ScanMag1*1 ScanPhase1 + (37*ScanPhaseShiftA + 38*ScanPhaseShiftB)
  1:1520: ScanMag1*1 ScanPhase1 + (37*ScanPhaseShiftA + 39*ScanPhaseShiftB)
  1:1521: ScanMag1*1 ScanPhase1 + (38*ScanPhaseShiftA + 0*ScanPhaseShiftB)
  1:1522: ScanMag1*1 ScanPhase1 + (38*ScanPhaseShiftA + 1*ScanPhaseShiftB)
  1:1523: ScanMag1*1 ScanPhase1 + (38*ScanPhaseShiftA + 2*ScanPhaseShiftB)
  1:1524: ScanMag1*1 ScanPhase1 + (38*ScanPhaseShiftA + 3*ScanPhaseShiftB)
  1:1525: ScanMag1*1 ScanPhase1 + (38*ScanPhaseShiftA + 4*ScanPhaseShiftB)
  1:1526: ScanMag1*1 ScanPhase1 + (38*ScanPhaseShiftA + 5*ScanPhaseShiftB)
  1:1527: ScanMag1*1 ScanPhase1 + (38*ScanPhaseShiftA + 6*ScanPhaseShiftB)
  1:1528: ScanMag1*1 ScanPhase1 + (38*ScanPhaseShiftA + 7*ScanPhaseShiftB)
  1:1529: ScanMag1*1 ScanPhase1 + (38*ScanPhaseShiftA + 8*ScanPhaseShiftB)
  1:1530: ScanMag1*1 ScanPhase1 + (38*ScanPhaseShiftA + 9*ScanPhaseShiftB)
  1:1531: ScanMag1*1 ScanPhase1 + (38*ScanPhaseShiftA + 10*ScanPhaseShiftB)
  1:1532: ScanMag1*1 ScanPhase1 + (38*ScanPhaseShiftA + 11*ScanPhaseShiftB)
  1:1533: ScanMag1*1 ScanPhase1 + (38*ScanPhaseShiftA + 12*ScanPhaseShiftB)
  1:1534: ScanMag1*1 ScanPhase1 + (38*ScanPhaseShiftA + 13*ScanPhaseShiftB)
  1:1535: ScanMag1*1 ScanPhase1 + (38*ScanPhaseShiftA + 14*ScanPhaseShiftB)
  1:1536: ScanMag1*1 ScanPhase1 + (38*ScanPhaseShiftA + 15*ScanPhaseShiftB)
  1:1537: ScanMag1*1 ScanPhase1 + (38*ScanPhaseShiftA + 16*ScanPhaseShiftB)
  1:1538: ScanMag1*1 ScanPhase1 + (38*ScanPhaseShiftA + 17*ScanPhaseShiftB)
  1:1539: ScanMag1*1 ScanPhase1 + (38*ScanPhaseShiftA + 18*ScanPhaseShiftB)
  1:1540: ScanMag1*1 ScanPhase1 + (38*ScanPhaseShiftA + 19*ScanPhaseShiftB)
  1:1541: ScanMag1*1 ScanPhase1 + (38*ScanPhaseShiftA + 20*ScanPhaseShiftB)
  1:1542: ScanMag1*1 ScanPhase1 + (38*ScanPhaseShiftA + 21*ScanPhaseShiftB)
  1:1543: ScanMag1*1 ScanPhase1 + (38*ScanPhaseShiftA + 22*ScanPhaseShiftB)
  1:1544: ScanMag1*1 ScanPhase1 + (38*ScanPhaseShiftA + 23*ScanPhaseShiftB)
  1:1545: ScanMag1*1 ScanPhase1 + (38*ScanPhaseShiftA + 24*ScanPhaseShiftB)
  1:1546: ScanMag1*1 ScanPhase1 + (38*ScanPhaseShiftA + 25*ScanPhaseShiftB)
  1:1547: ScanMag1*1 ScanPhase1 + (38*ScanPhaseShiftA + 26*ScanPhaseShiftB)
  1:1548: ScanMag1*1 ScanPhase1 + (38*ScanPhaseShiftA + 27*ScanPhaseShiftB)
  1:1549: ScanMag1*1 ScanPhase1 + (38*ScanPhaseShiftA + 28*ScanPhaseShiftB)
  1:1550: ScanMag1*1 ScanPhase1 + (38*ScanPhaseShiftA + 29*ScanPhaseShiftB)
  1:1551: ScanMag1*1 ScanPhase1 + (38*ScanPhaseShiftA + 30*ScanPhaseShiftB)
  1:1552: ScanMag1*1 ScanPhase1 + (38*ScanPhaseShiftA + 31*ScanPhaseShiftB)
  1:1553: ScanMag1*1 ScanPhase1 + (38*ScanPhaseShiftA + 32*ScanPhaseShiftB)
  1:1554: ScanMag1*1 ScanPhase1 + (38*ScanPhaseShiftA + 33*ScanPhaseShiftB)
  1:1555: ScanMag1*1 ScanPhase1 + (38*ScanPhaseShiftA + 34*ScanPhaseShiftB)
  1:1556: ScanMag1*1 ScanPhase1 + (38*ScanPhaseShiftA + 35*ScanPhaseShiftB)
  1:1557: ScanMag1*1 ScanPhase1 + (38*ScanPhaseShiftA + 36*ScanPhaseShiftB)
  1:1558: ScanMag1*1 ScanPhase1 + (38*ScanPhaseShiftA + 37*ScanPhaseShiftB)
  1:1559: ScanMag1*1 ScanPhase1 + (38*ScanPhaseShiftA + 38*ScanPhaseShiftB)
  1:1560: ScanMag1*1 ScanPhase1 + (38*ScanPhaseShiftA + 39*ScanPhaseShiftB)
  1:1561: ScanMag1*1 ScanPhase1 + (39*ScanPhaseShiftA + 0*ScanPhaseShiftB)
  1:1562: ScanMag1*1 ScanPhase1 + (39*ScanPhaseShiftA + 1*ScanPhaseShiftB)
  1:1563: ScanMag1*1 ScanPhase1 + (39*ScanPhaseShiftA + 2*ScanPhaseShiftB)
  1:1564: ScanMag1*1 ScanPhase1 + (39*ScanPhaseShiftA + 3*ScanPhaseShiftB)
  1:1565: ScanMag1*1 ScanPhase1 + (39*ScanPhaseShiftA + 4*ScanPhaseShiftB)
  1:1566: ScanMag1*1 ScanPhase1 + (39*ScanPhaseShiftA + 5*ScanPhaseShiftB)
  1:1567: ScanMag1*1 ScanPhase1 + (39*ScanPhaseShiftA + 6*ScanPhaseShiftB)
  1:1568: ScanMag1*1 ScanPhase1 + (39*ScanPhaseShiftA + 7*ScanPhaseShiftB)
  1:1569: ScanMag1*1 ScanPhase1 + (39*ScanPhaseShiftA + 8*ScanPhaseShiftB)
  1:1570: ScanMag1*1 ScanPhase1 + (39*ScanPhaseShiftA + 9*ScanPhaseShiftB)
  1:1571: ScanMag1*1 ScanPhase1 + (39*ScanPhaseShiftA + 10*ScanPhaseShiftB)
  1:1572: ScanMag1*1 ScanPhase1 + (39*ScanPhaseShiftA + 11*ScanPhaseShiftB)
  1:1573: ScanMag1*1 ScanPhase1 + (39*ScanPhaseShiftA + 12*ScanPhaseShiftB)
  1:1574: ScanMag1*1 ScanPhase1 + (39*ScanPhaseShiftA + 13*ScanPhaseShiftB)
  1:1575: ScanMag1*1 ScanPhase1 + (39*ScanPhaseShiftA + 14*ScanPhaseShiftB)
  1:1576: ScanMag1*1 ScanPhase1 + (39*ScanPhaseShiftA + 15*ScanPhaseShiftB)
  1:1577: ScanMag1*1 ScanPhase1 + (39*ScanPhaseShiftA + 16*ScanPhaseShiftB)
  1:1578: ScanMag1*1 ScanPhase1 + (39*ScanPhaseShiftA + 17*ScanPhaseShiftB)
  1:1579: ScanMag1*1 ScanPhase1 + (39*ScanPhaseShiftA + 18*ScanPhaseShiftB)
  1:1580: ScanMag1*1 ScanPhase1 + (39*ScanPhaseShiftA + 19*ScanPhaseShiftB)
  1:1581: ScanMag1*1 ScanPhase1 + (39*ScanPhaseShiftA + 20*ScanPhaseShiftB)
  1:1582: ScanMag1*1 ScanPhase1 + (39*ScanPhaseShiftA + 21*ScanPhaseShiftB)
  1:1583: ScanMag1*1 ScanPhase1 + (39*ScanPhaseShiftA + 22*ScanPhaseShiftB)
  1:1584: ScanMag1*1 ScanPhase1 + (39*ScanPhaseShiftA + 23*ScanPhaseShiftB)
  1:1585: ScanMag1*1 ScanPhase1 + (39*ScanPhaseShiftA + 24*ScanPhaseShiftB)
  1:1586: ScanMag1*1 ScanPhase1 + (39*ScanPhaseShiftA + 25*ScanPhaseShiftB)
  1:1587: ScanMag1*1 ScanPhase1 + (39*ScanPhaseShiftA + 26*ScanPhaseShiftB)
  1:1588: ScanMag1*1 ScanPhase1 + (39*ScanPhaseShiftA + 27*ScanPhaseShiftB)
  1:1589: ScanMag1*1 ScanPhase1 + (39*ScanPhaseShiftA + 28*ScanPhaseShiftB)
  1:1590: ScanMag1*1 ScanPhase1 + (39*ScanPhaseShiftA + 29*ScanPhaseShiftB)
  1:1591: ScanMag1*1 ScanPhase1 + (39*ScanPhaseShiftA + 30*ScanPhaseShiftB)
  1:1592: ScanMag1*1 ScanPhase1 + (39*ScanPhaseShiftA + 31*ScanPhaseShiftB)
  1:1593: ScanMag1*1 ScanPhase1 + (39*ScanPhaseShiftA + 32*ScanPhaseShiftB)
  1:1594: ScanMag1*1 ScanPhase1 + (39*ScanPhaseShiftA + 33*ScanPhaseShiftB)
  1:1595: ScanMag1*1 ScanPhase1 + (39*ScanPhaseShiftA + 34*ScanPhaseShiftB)
  1:1596: ScanMag1*1 ScanPhase1 + (39*ScanPhaseShiftA + 35*ScanPhaseShiftB)
  1:1597: ScanMag1*1 ScanPhase1 + (39*ScanPhaseShiftA + 36*ScanPhaseShiftB)
  1:1598: ScanMag1*1 ScanPhase1 + (39*ScanPhaseShiftA + 37*ScanPhaseShiftB)
  1:1599: ScanMag1*1 ScanPhase1 + (39*ScanPhaseShiftA + 38*ScanPhaseShiftB)
  1:1600: ScanMag1*1 ScanPhase1 + (39*ScanPhaseShiftA + 39*ScanPhaseShiftB)
  2:1: ScanMag2*1 ScanPhase2 + (0*ScanPhaseShiftA + 0*ScanPhaseShiftB)
  2:2: ScanMag2*1 ScanPhase2 + (0*ScanPhaseShiftA + 1*ScanPhaseShiftB)
  2:3: ScanMag2*1 ScanPhase2 + (0*ScanPhaseShiftA + 2*ScanPhaseShiftB)
  2:4: ScanMag2*1 ScanPhase2 + (0*ScanPhaseShiftA + 3*ScanPhaseShiftB)
  2:5: ScanMag2*1 ScanPhase2 + (0*ScanPhaseShiftA + 4*ScanPhaseShiftB)
  2:6: ScanMag2*1 ScanPhase2 + (0*ScanPhaseShiftA + 5*ScanPhaseShiftB)
  2:7: ScanMag2*1 ScanPhase2 + (0*ScanPhaseShiftA + 6*ScanPhaseShiftB)
  2:8: ScanMag2*1 ScanPhase2 + (0*ScanPhaseShiftA + 7*ScanPhaseShiftB)
  2:9: ScanMag2*1 ScanPhase2 + (0*ScanPhaseShiftA + 8*ScanPhaseShiftB)
  2:10: ScanMag2*1 ScanPhase2 + (0*ScanPhaseShiftA + 9*ScanPhaseShiftB)
  2:11: ScanMag2*1 ScanPhase2 + (0*ScanPhaseShiftA + 10*ScanPhaseShiftB)
  2:12: ScanMag2*1 ScanPhase2 + (0*ScanPhaseShiftA + 11*ScanPhaseShiftB)
  2:13: ScanMag2*1 ScanPhase2 + (0*ScanPhaseShiftA + 12*ScanPhaseShiftB)
  2:14: ScanMag2*1 ScanPhase2 + (0*ScanPhaseShiftA + 13*ScanPhaseShiftB)
  2:15: ScanMag2*1 ScanPhase2 + (0*ScanPhaseShiftA + 14*ScanPhaseShiftB)
  2:16: ScanMag2*1 ScanPhase2 + (0*ScanPhaseShiftA + 15*ScanPhaseShiftB)
  2:17: ScanMag2*1 ScanPhase2 + (0*ScanPhaseShiftA + 16*ScanPhaseShiftB)
  2:18: ScanMag2*1 ScanPhase2 + (0*ScanPhaseShiftA + 17*ScanPhaseShiftB)
  2:19: ScanMag2*1 ScanPhase2 + (0*ScanPhaseShiftA + 18*ScanPhaseShiftB)
  2:20: ScanMag2*1 ScanPhase2 + (0*ScanPhaseShiftA + 19*ScanPhaseShiftB)
  2:21: ScanMag2*1 ScanPhase2 + (0*ScanPhaseShiftA + 20*ScanPhaseShiftB)
  2:22: ScanMag2*1 ScanPhase2 + (0*ScanPhaseShiftA + 21*ScanPhaseShiftB)
  2:23: ScanMag2*1 ScanPhase2 + (0*ScanPhaseShiftA + 22*ScanPhaseShiftB)
  2:24: ScanMag2*1 ScanPhase2 + (0*ScanPhaseShiftA + 23*ScanPhaseShiftB)
  2:25: ScanMag2*1 ScanPhase2 + (0*ScanPhaseShiftA + 24*ScanPhaseShiftB)
  2:26: ScanMag2*1 ScanPhase2 + (0*ScanPhaseShiftA + 25*ScanPhaseShiftB)
  2:27: ScanMag2*1 ScanPhase2 + (0*ScanPhaseShiftA + 26*ScanPhaseShiftB)
  2:28: ScanMag2*1 ScanPhase2 + (0*ScanPhaseShiftA + 27*ScanPhaseShiftB)
  2:29: ScanMag2*1 ScanPhase2 + (0*ScanPhaseShiftA + 28*ScanPhaseShiftB)
  2:30: ScanMag2*1 ScanPhase2 + (0*ScanPhaseShiftA + 29*ScanPhaseShiftB)
  2:31: ScanMag2*1 ScanPhase2 + (0*ScanPhaseShiftA + 30*ScanPhaseShiftB)
  2:32: ScanMag2*1 ScanPhase2 + (0*ScanPhaseShiftA + 31*ScanPhaseShiftB)
  2:33: ScanMag2*1 ScanPhase2 + (0*ScanPhaseShiftA + 32*ScanPhaseShiftB)
  2:34: ScanMag2*1 ScanPhase2 + (0*ScanPhaseShiftA + 33*ScanPhaseShiftB)
  2:35: ScanMag2*1 ScanPhase2 + (0*ScanPhaseShiftA + 34*ScanPhaseShiftB)
  2:36: ScanMag2*1 ScanPhase2 + (0*ScanPhaseShiftA + 35*ScanPhaseShiftB)
  2:37: ScanMag2*1 ScanPhase2 + (0*ScanPhaseShiftA + 36*ScanPhaseShiftB)
  2:38: ScanMag2*1 ScanPhase2 + (0*ScanPhaseShiftA + 37*ScanPhaseShiftB)
  2:39: ScanMag2*1 ScanPhase2 + (0*ScanPhaseShiftA + 38*ScanPhaseShiftB)
  2:40: ScanMag2*1 ScanPhase2 + (0*ScanPhaseShiftA + 39*ScanPhaseShiftB)
  2:41: ScanMag2*1 ScanPhase2 + (1*ScanPhaseShiftA + 0*ScanPhaseShiftB)
  2:42: ScanMag2*1 ScanPhase2 + (1*ScanPhaseShiftA + 1*ScanPhaseShiftB)
  2:43: ScanMag2*1 ScanPhase2 + (1*ScanPhaseShiftA + 2*ScanPhaseShiftB)
  2:44: ScanMag2*1 ScanPhase2 + (1*ScanPhaseShiftA + 3*ScanPhaseShiftB)
  2:45: ScanMag2*1 ScanPhase2 + (1*ScanPhaseShiftA + 4*ScanPhaseShiftB)
  2:46: ScanMag2*1 ScanPhase2 + (1*ScanPhaseShiftA + 5*ScanPhaseShiftB)
  2:47: ScanMag2*1 ScanPhase2 + (1*ScanPhaseShiftA + 6*ScanPhaseShiftB)
  2:48: ScanMag2*1 ScanPhase2 + (1*ScanPhaseShiftA + 7*ScanPhaseShiftB)
  2:49: ScanMag2*1 ScanPhase2 + (1*ScanPhaseShiftA + 8*ScanPhaseShiftB)
  2:50: ScanMag2*1 ScanPhase2 + (1*ScanPhaseShiftA + 9*ScanPhaseShiftB)
  2:51: ScanMag2*1 ScanPhase2 + (1*ScanPhaseShiftA + 10*ScanPhaseShiftB)
  2:52: ScanMag2*1 ScanPhase2 + (1*ScanPhaseShiftA + 11*ScanPhaseShiftB)
  2:53: ScanMag2*1 ScanPhase2 + (1*ScanPhaseShiftA + 12*ScanPhaseShiftB)
  2:54: ScanMag2*1 ScanPhase2 + (1*ScanPhaseShiftA + 13*ScanPhaseShiftB)
  2:55: ScanMag2*1 ScanPhase2 + (1*ScanPhaseShiftA + 14*ScanPhaseShiftB)
  2:56: ScanMag2*1 ScanPhase2 + (1*ScanPhaseShiftA + 15*ScanPhaseShiftB)
  2:57: ScanMag2*1 ScanPhase2 + (1*ScanPhaseShiftA + 16*ScanPhaseShiftB)
  2:58: ScanMag2*1 ScanPhase2 + (1*ScanPhaseShiftA + 17*ScanPhaseShiftB)
  2:59: ScanMag2*1 ScanPhase2 + (1*ScanPhaseShiftA + 18*ScanPhaseShiftB)
  2:60: ScanMag2*1 ScanPhase2 + (1*ScanPhaseShiftA + 19*ScanPhaseShiftB)
  2:61: ScanMag2*1 ScanPhase2 + (1*ScanPhaseShiftA + 20*ScanPhaseShiftB)
  2:62: ScanMag2*1 ScanPhase2 + (1*ScanPhaseShiftA + 21*ScanPhaseShiftB)
  2:63: ScanMag2*1 ScanPhase2 + (1*ScanPhaseShiftA + 22*ScanPhaseShiftB)
  2:64: ScanMag2*1 ScanPhase2 + (1*ScanPhaseShiftA + 23*ScanPhaseShiftB)
  2:65: ScanMag2*1 ScanPhase2 + (1*ScanPhaseShiftA + 24*ScanPhaseShiftB)
  2:66: ScanMag2*1 ScanPhase2 + (1*ScanPhaseShiftA + 25*ScanPhaseShiftB)
  2:67: ScanMag2*1 ScanPhase2 + (1*ScanPhaseShiftA + 26*ScanPhaseShiftB)
  2:68: ScanMag2*1 ScanPhase2 + (1*ScanPhaseShiftA + 27*ScanPhaseShiftB)
  2:69: ScanMag2*1 ScanPhase2 + (1*ScanPhaseShiftA + 28*ScanPhaseShiftB)
  2:70: ScanMag2*1 ScanPhase2 + (1*ScanPhaseShiftA + 29*ScanPhaseShiftB)
  2:71: ScanMag2*1 ScanPhase2 + (1*ScanPhaseShiftA + 30*ScanPhaseShiftB)
  2:72: ScanMag2*1 ScanPhase2 + (1*ScanPhaseShiftA + 31*ScanPhaseShiftB)
  2:73: ScanMag2*1 ScanPhase2 + (1*ScanPhaseShiftA + 32*ScanPhaseShiftB)
  2:74: ScanMag2*1 ScanPhase2 + (1*ScanPhaseShiftA + 33*ScanPhaseShiftB)
  2:75: ScanMag2*1 ScanPhase2 + (1*ScanPhaseShiftA + 34*ScanPhaseShiftB)
  2:76: ScanMag2*1 ScanPhase2 + (1*ScanPhaseShiftA + 35*ScanPhaseShiftB)
  2:77: ScanMag2*1 ScanPhase2 + (1*ScanPhaseShiftA + 36*ScanPhaseShiftB)
  2:78: ScanMag2*1 ScanPhase2 + (1*ScanPhaseShiftA + 37*ScanPhaseShiftB)
  2:79: ScanMag2*1 ScanPhase2 + (1*ScanPhaseShiftA + 38*ScanPhaseShiftB)
  2:80: ScanMag2*1 ScanPhase2 + (1*ScanPhaseShiftA + 39*ScanPhaseShiftB)
  2:81: ScanMag2*1 ScanPhase2 + (2*ScanPhaseShiftA + 0*ScanPhaseShiftB)
  2:82: ScanMag2*1 ScanPhase2 + (2*ScanPhaseShiftA + 1*ScanPhaseShiftB)
  2:83: ScanMag2*1 ScanPhase2 + (2*ScanPhaseShiftA + 2*ScanPhaseShiftB)
  2:84: ScanMag2*1 ScanPhase2 + (2*ScanPhaseShiftA + 3*ScanPhaseShiftB)
  2:85: ScanMag2*1 ScanPhase2 + (2*ScanPhaseShiftA + 4*ScanPhaseShiftB)
  2:86: ScanMag2*1 ScanPhase2 + (2*ScanPhaseShiftA + 5*ScanPhaseShiftB)
  2:87: ScanMag2*1 ScanPhase2 + (2*ScanPhaseShiftA + 6*ScanPhaseShiftB)
  2:88: ScanMag2*1 ScanPhase2 + (2*ScanPhaseShiftA + 7*ScanPhaseShiftB)
  2:89: ScanMag2*1 ScanPhase2 + (2*ScanPhaseShiftA + 8*ScanPhaseShiftB)
  2:90: ScanMag2*1 ScanPhase2 + (2*ScanPhaseShiftA + 9*ScanPhaseShiftB)
  2:91: ScanMag2*1 ScanPhase2 + (2*ScanPhaseShiftA + 10*ScanPhaseShiftB)
  2:92: ScanMag2*1 ScanPhase2 + (2*ScanPhaseShiftA + 11*ScanPhaseShiftB)
  2:93: ScanMag2*1 ScanPhase2 + (2*ScanPhaseShiftA + 12*ScanPhaseShiftB)
  2:94: ScanMag2*1 ScanPhase2 + (2*ScanPhaseShiftA + 13*ScanPhaseShiftB)
  2:95: ScanMag2*1 ScanPhase2 + (2*ScanPhaseShiftA + 14*ScanPhaseShiftB)
  2:96: ScanMag2*1 ScanPhase2 + (2*ScanPhaseShiftA + 15*ScanPhaseShiftB)
  2:97: ScanMag2*1 ScanPhase2 + (2*ScanPhaseShiftA + 16*ScanPhaseShiftB)
  2:98: ScanMag2*1 ScanPhase2 + (2*ScanPhaseShiftA + 17*ScanPhaseShiftB)
  2:99: ScanMag2*1 ScanPhase2 + (2*ScanPhaseShiftA + 18*ScanPhaseShiftB)
  2:100: ScanMag2*1 ScanPhase2 + (2*ScanPhaseShiftA + 19*ScanPhaseShiftB)
  2:101: ScanMag2*1 ScanPhase2 + (2*ScanPhaseShiftA + 20*ScanPhaseShiftB)
  2:102: ScanMag2*1 ScanPhase2 + (2*ScanPhaseShiftA + 21*ScanPhaseShiftB)
  2:103: ScanMag2*1 ScanPhase2 + (2*ScanPhaseShiftA + 22*ScanPhaseShiftB)
  2:104: ScanMag2*1 ScanPhase2 + (2*ScanPhaseShiftA + 23*ScanPhaseShiftB)
  2:105: ScanMag2*1 ScanPhase2 + (2*ScanPhaseShiftA + 24*ScanPhaseShiftB)
  2:106: ScanMag2*1 ScanPhase2 + (2*ScanPhaseShiftA + 25*ScanPhaseShiftB)
  2:107: ScanMag2*1 ScanPhase2 + (2*ScanPhaseShiftA + 26*ScanPhaseShiftB)
  2:108: ScanMag2*1 ScanPhase2 + (2*ScanPhaseShiftA + 27*ScanPhaseShiftB)
  2:109: ScanMag2*1 ScanPhase2 + (2*ScanPhaseShiftA + 28*ScanPhaseShiftB)
  2:110: ScanMag2*1 ScanPhase2 + (2*ScanPhaseShiftA + 29*ScanPhaseShiftB)
  2:111: ScanMag2*1 ScanPhase2 + (2*ScanPhaseShiftA + 30*ScanPhaseShiftB)
  2:112: ScanMag2*1 ScanPhase2 + (2*ScanPhaseShiftA + 31*ScanPhaseShiftB)
  2:113: ScanMag2*1 ScanPhase2 + (2*ScanPhaseShiftA + 32*ScanPhaseShiftB)
  2:114: ScanMag2*1 ScanPhase2 + (2*ScanPhaseShiftA + 33*ScanPhaseShiftB)
  2:115: ScanMag2*1 ScanPhase2 + (2*ScanPhaseShiftA + 34*ScanPhaseShiftB)
  2:116: ScanMag2*1 ScanPhase2 + (2*ScanPhaseShiftA + 35*ScanPhaseShiftB)
  2:117: ScanMag2*1 ScanPhase2 + (2*ScanPhaseShiftA + 36*ScanPhaseShiftB)
  2:118: ScanMag2*1 ScanPhase2 + (2*ScanPhaseShiftA + 37*ScanPhaseShiftB)
  2:119: ScanMag2*1 ScanPhase2 + (2*ScanPhaseShiftA + 38*ScanPhaseShiftB)
  2:120: ScanMag2*1 ScanPhase2 + (2*ScanPhaseShiftA + 39*ScanPhaseShiftB)
  2:121: ScanMag2*1 ScanPhase2 + (3*ScanPhaseShiftA + 0*ScanPhaseShiftB)
  2:122: ScanMag2*1 ScanPhase2 + (3*ScanPhaseShiftA + 1*ScanPhaseShiftB)
  2:123: ScanMag2*1 ScanPhase2 + (3*ScanPhaseShiftA + 2*ScanPhaseShiftB)
  2:124: ScanMag2*1 ScanPhase2 + (3*ScanPhaseShiftA + 3*ScanPhaseShiftB)
  2:125: ScanMag2*1 ScanPhase2 + (3*ScanPhaseShiftA + 4*ScanPhaseShiftB)
  2:126: ScanMag2*1 ScanPhase2 + (3*ScanPhaseShiftA + 5*ScanPhaseShiftB)
  2:127: ScanMag2*1 ScanPhase2 + (3*ScanPhaseShiftA + 6*ScanPhaseShiftB)
  2:128: ScanMag2*1 ScanPhase2 + (3*ScanPhaseShiftA + 7*ScanPhaseShiftB)
  2:129: ScanMag2*1 ScanPhase2 + (3*ScanPhaseShiftA + 8*ScanPhaseShiftB)
  2:130: ScanMag2*1 ScanPhase2 + (3*ScanPhaseShiftA + 9*ScanPhaseShiftB)
  2:131: ScanMag2*1 ScanPhase2 + (3*ScanPhaseShiftA + 10*ScanPhaseShiftB)
  2:132: ScanMag2*1 ScanPhase2 + (3*ScanPhaseShiftA + 11*ScanPhaseShiftB)
  2:133: ScanMag2*1 ScanPhase2 + (3*ScanPhaseShiftA + 12*ScanPhaseShiftB)
  2:134: ScanMag2*1 ScanPhase2 + (3*ScanPhaseShiftA + 13*ScanPhaseShiftB)
  2:135: ScanMag2*1 ScanPhase2 + (3*ScanPhaseShiftA + 14*ScanPhaseShiftB)
  2:136: ScanMag2*1 ScanPhase2 + (3*ScanPhaseShiftA + 15*ScanPhaseShiftB)
  2:137: ScanMag2*1 ScanPhase2 + (3*ScanPhaseShiftA + 16*ScanPhaseShiftB)
  2:138: ScanMag2*1 ScanPhase2 + (3*ScanPhaseShiftA + 17*ScanPhaseShiftB)
  2:139: ScanMag2*1 ScanPhase2 + (3*ScanPhaseShiftA + 18*ScanPhaseShiftB)
  2:140: ScanMag2*1 ScanPhase2 + (3*ScanPhaseShiftA + 19*ScanPhaseShiftB)
  2:141: ScanMag2*1 ScanPhase2 + (3*ScanPhaseShiftA + 20*ScanPhaseShiftB)
  2:142: ScanMag2*1 ScanPhase2 + (3*ScanPhaseShiftA + 21*ScanPhaseShiftB)
  2:143: ScanMag2*1 ScanPhase2 + (3*ScanPhaseShiftA + 22*ScanPhaseShiftB)
  2:144: ScanMag2*1 ScanPhase2 + (3*ScanPhaseShiftA + 23*ScanPhaseShiftB)
  2:145: ScanMag2*1 ScanPhase2 + (3*ScanPhaseShiftA + 24*ScanPhaseShiftB)
  2:146: ScanMag2*1 ScanPhase2 + (3*ScanPhaseShiftA + 25*ScanPhaseShiftB)
  2:147: ScanMag2*1 ScanPhase2 + (3*ScanPhaseShiftA + 26*ScanPhaseShiftB)
  2:148: ScanMag2*1 ScanPhase2 + (3*ScanPhaseShiftA + 27*ScanPhaseShiftB)
  2:149: ScanMag2*1 ScanPhase2 + (3*ScanPhaseShiftA + 28*ScanPhaseShiftB)
  2:150: ScanMag2*1 ScanPhase2 + (3*ScanPhaseShiftA + 29*ScanPhaseShiftB)
  2:151: ScanMag2*1 ScanPhase2 + (3*ScanPhaseShiftA + 30*ScanPhaseShiftB)
  2:152: ScanMag2*1 ScanPhase2 + (3*ScanPhaseShiftA + 31*ScanPhaseShiftB)
  2:153: ScanMag2*1 ScanPhase2 + (3*ScanPhaseShiftA + 32*ScanPhaseShiftB)
  2:154: ScanMag2*1 ScanPhase2 + (3*ScanPhaseShiftA + 33*ScanPhaseShiftB)
  2:155: ScanMag2*1 ScanPhase2 + (3*ScanPhaseShiftA + 34*ScanPhaseShiftB)
  2:156: ScanMag2*1 ScanPhase2 + (3*ScanPhaseShiftA + 35*ScanPhaseShiftB)
  2:157: ScanMag2*1 ScanPhase2 + (3*ScanPhaseShiftA + 36*ScanPhaseShiftB)
  2:158: ScanMag2*1 ScanPhase2 + (3*ScanPhaseShiftA + 37*ScanPhaseShiftB)
  2:159: ScanMag2*1 ScanPhase2 + (3*ScanPhaseShiftA + 38*ScanPhaseShiftB)
  2:160: ScanMag2*1 ScanPhase2 + (3*ScanPhaseShiftA + 39*ScanPhaseShiftB)
  2:161: ScanMag2*1 ScanPhase2 + (4*ScanPhaseShiftA + 0*ScanPhaseShiftB)
  2:162: ScanMag2*1 ScanPhase2 + (4*ScanPhaseShiftA + 1*ScanPhaseShiftB)
  2:163: ScanMag2*1 ScanPhase2 + (4*ScanPhaseShiftA + 2*ScanPhaseShiftB)
  2:164: ScanMag2*1 ScanPhase2 + (4*ScanPhaseShiftA + 3*ScanPhaseShiftB)
  2:165: ScanMag2*1 ScanPhase2 + (4*ScanPhaseShiftA + 4*ScanPhaseShiftB)
  2:166: ScanMag2*1 ScanPhase2 + (4*ScanPhaseShiftA + 5*ScanPhaseShiftB)
  2:167: ScanMag2*1 ScanPhase2 + (4*ScanPhaseShiftA + 6*ScanPhaseShiftB)
  2:168: ScanMag2*1 ScanPhase2 + (4*ScanPhaseShiftA + 7*ScanPhaseShiftB)
  2:169: ScanMag2*1 ScanPhase2 + (4*ScanPhaseShiftA + 8*ScanPhaseShiftB)
  2:170: ScanMag2*1 ScanPhase2 + (4*ScanPhaseShiftA + 9*ScanPhaseShiftB)
  2:171: ScanMag2*1 ScanPhase2 + (4*ScanPhaseShiftA + 10*ScanPhaseShiftB)
  2:172: ScanMag2*1 ScanPhase2 + (4*ScanPhaseShiftA + 11*ScanPhaseShiftB)
  2:173: ScanMag2*1 ScanPhase2 + (4*ScanPhaseShiftA + 12*ScanPhaseShiftB)
  2:174: ScanMag2*1 ScanPhase2 + (4*ScanPhaseShiftA + 13*ScanPhaseShiftB)
  2:175: ScanMag2*1 ScanPhase2 + (4*ScanPhaseShiftA + 14*ScanPhaseShiftB)
  2:176: ScanMag2*1 ScanPhase2 + (4*ScanPhaseShiftA + 15*ScanPhaseShiftB)
  2:177: ScanMag2*1 ScanPhase2 + (4*ScanPhaseShiftA + 16*ScanPhaseShiftB)
  2:178: ScanMag2*1 ScanPhase2 + (4*ScanPhaseShiftA + 17*ScanPhaseShiftB)
  2:179: ScanMag2*1 ScanPhase2 + (4*ScanPhaseShiftA + 18*ScanPhaseShiftB)
  2:180: ScanMag2*1 ScanPhase2 + (4*ScanPhaseShiftA + 19*ScanPhaseShiftB)
  2:181: ScanMag2*1 ScanPhase2 + (4*ScanPhaseShiftA + 20*ScanPhaseShiftB)
  2:182: ScanMag2*1 ScanPhase2 + (4*ScanPhaseShiftA + 21*ScanPhaseShiftB)
  2:183: ScanMag2*1 ScanPhase2 + (4*ScanPhaseShiftA + 22*ScanPhaseShiftB)
  2:184: ScanMag2*1 ScanPhase2 + (4*ScanPhaseShiftA + 23*ScanPhaseShiftB)
  2:185: ScanMag2*1 ScanPhase2 + (4*ScanPhaseShiftA + 24*ScanPhaseShiftB)
  2:186: ScanMag2*1 ScanPhase2 + (4*ScanPhaseShiftA + 25*ScanPhaseShiftB)
  2:187: ScanMag2*1 ScanPhase2 + (4*ScanPhaseShiftA + 26*ScanPhaseShiftB)
  2:188: ScanMag2*1 ScanPhase2 + (4*ScanPhaseShiftA + 27*ScanPhaseShiftB)
  2:189: ScanMag2*1 ScanPhase2 + (4*ScanPhaseShiftA + 28*ScanPhaseShiftB)
  2:190: ScanMag2*1 ScanPhase2 + (4*ScanPhaseShiftA + 29*ScanPhaseShiftB)
  2:191: ScanMag2*1 ScanPhase2 + (4*ScanPhaseShiftA + 30*ScanPhaseShiftB)
  2:192: ScanMag2*1 ScanPhase2 + (4*ScanPhaseShiftA + 31*ScanPhaseShiftB)
  2:193: ScanMag2*1 ScanPhase2 + (4*ScanPhaseShiftA + 32*ScanPhaseShiftB)
  2:194: ScanMag2*1 ScanPhase2 + (4*ScanPhaseShiftA + 33*ScanPhaseShiftB)
  2:195: ScanMag2*1 ScanPhase2 + (4*ScanPhaseShiftA + 34*ScanPhaseShiftB)
  2:196: ScanMag2*1 ScanPhase2 + (4*ScanPhaseShiftA + 35*ScanPhaseShiftB)
  2:197: ScanMag2*1 ScanPhase2 + (4*ScanPhaseShiftA + 36*ScanPhaseShiftB)
  2:198: ScanMag2*1 ScanPhase2 + (4*ScanPhaseShiftA + 37*ScanPhaseShiftB)
  2:199: ScanMag2*1 ScanPhase2 + (4*ScanPhaseShiftA + 38*ScanPhaseShiftB)
  2:200: ScanMag2*1 ScanPhase2 + (4*ScanPhaseShiftA + 39*ScanPhaseShiftB)
  2:201: ScanMag2*1 ScanPhase2 + (5*ScanPhaseShiftA + 0*ScanPhaseShiftB)
  2:202: ScanMag2*1 ScanPhase2 + (5*ScanPhaseShiftA + 1*ScanPhaseShiftB)
  2:203: ScanMag2*1 ScanPhase2 + (5*ScanPhaseShiftA + 2*ScanPhaseShiftB)
  2:204: ScanMag2*1 ScanPhase2 + (5*ScanPhaseShiftA + 3*ScanPhaseShiftB)
  2:205: ScanMag2*1 ScanPhase2 + (5*ScanPhaseShiftA + 4*ScanPhaseShiftB)
  2:206: ScanMag2*1 ScanPhase2 + (5*ScanPhaseShiftA + 5*ScanPhaseShiftB)
  2:207: ScanMag2*1 ScanPhase2 + (5*ScanPhaseShiftA + 6*ScanPhaseShiftB)
  2:208: ScanMag2*1 ScanPhase2 + (5*ScanPhaseShiftA + 7*ScanPhaseShiftB)
  2:209: ScanMag2*1 ScanPhase2 + (5*ScanPhaseShiftA + 8*ScanPhaseShiftB)
  2:210: ScanMag2*1 ScanPhase2 + (5*ScanPhaseShiftA + 9*ScanPhaseShiftB)
  2:211: ScanMag2*1 ScanPhase2 + (5*ScanPhaseShiftA + 10*ScanPhaseShiftB)
  2:212: ScanMag2*1 ScanPhase2 + (5*ScanPhaseShiftA + 11*ScanPhaseShiftB)
  2:213: ScanMag2*1 ScanPhase2 + (5*ScanPhaseShiftA + 12*ScanPhaseShiftB)
  2:214: ScanMag2*1 ScanPhase2 + (5*ScanPhaseShiftA + 13*ScanPhaseShiftB)
  2:215: ScanMag2*1 ScanPhase2 + (5*ScanPhaseShiftA + 14*ScanPhaseShiftB)
  2:216: ScanMag2*1 ScanPhase2 + (5*ScanPhaseShiftA + 15*ScanPhaseShiftB)
  2:217: ScanMag2*1 ScanPhase2 + (5*ScanPhaseShiftA + 16*ScanPhaseShiftB)
  2:218: ScanMag2*1 ScanPhase2 + (5*ScanPhaseShiftA + 17*ScanPhaseShiftB)
  2:219: ScanMag2*1 ScanPhase2 + (5*ScanPhaseShiftA + 18*ScanPhaseShiftB)
  2:220: ScanMag2*1 ScanPhase2 + (5*ScanPhaseShiftA + 19*ScanPhaseShiftB)
  2:221: ScanMag2*1 ScanPhase2 + (5*ScanPhaseShiftA + 20*ScanPhaseShiftB)
  2:222: ScanMag2*1 ScanPhase2 + (5*ScanPhaseShiftA + 21*ScanPhaseShiftB)
  2:223: ScanMag2*1 ScanPhase2 + (5*ScanPhaseShiftA + 22*ScanPhaseShiftB)
  2:224: ScanMag2*1 ScanPhase2 + (5*ScanPhaseShiftA + 23*ScanPhaseShiftB)
  2:225: ScanMag2*1 ScanPhase2 + (5*ScanPhaseShiftA + 24*ScanPhaseShiftB)
  2:226: ScanMag2*1 ScanPhase2 + (5*ScanPhaseShiftA + 25*ScanPhaseShiftB)
  2:227: ScanMag2*1 ScanPhase2 + (5*ScanPhaseShiftA + 26*ScanPhaseShiftB)
  2:228: ScanMag2*1 ScanPhase2 + (5*ScanPhaseShiftA + 27*ScanPhaseShiftB)
  2:229: ScanMag2*1 ScanPhase2 + (5*ScanPhaseShiftA + 28*ScanPhaseShiftB)
  2:230: ScanMag2*1 ScanPhase2 + (5*ScanPhaseShiftA + 29*ScanPhaseShiftB)
  2:231: ScanMag2*1 ScanPhase2 + (5*ScanPhaseShiftA + 30*ScanPhaseShiftB)
  2:232: ScanMag2*1 ScanPhase2 + (5*ScanPhaseShiftA + 31*ScanPhaseShiftB)
  2:233: ScanMag2*1 ScanPhase2 + (5*ScanPhaseShiftA + 32*ScanPhaseShiftB)
  2:234: ScanMag2*1 ScanPhase2 + (5*ScanPhaseShiftA + 33*ScanPhaseShiftB)
  2:235: ScanMag2*1 ScanPhase2 + (5*ScanPhaseShiftA + 34*ScanPhaseShiftB)
  2:236: ScanMag2*1 ScanPhase2 + (5*ScanPhaseShiftA + 35*ScanPhaseShiftB)
  2:237: ScanMag2*1 ScanPhase2 + (5*ScanPhaseShiftA + 36*ScanPhaseShiftB)
  2:238: ScanMag2*1 ScanPhase2 + (5*ScanPhaseShiftA + 37*ScanPhaseShiftB)
  2:239: ScanMag2*1 ScanPhase2 + (5*ScanPhaseShiftA + 38*ScanPhaseShiftB)
  2:240: ScanMag2*1 ScanPhase2 + (5*ScanPhaseShiftA + 39*ScanPhaseShiftB)
  2:241: ScanMag2*1 ScanPhase2 + (6*ScanPhaseShiftA + 0*ScanPhaseShiftB)
  2:242: ScanMag2*1 ScanPhase2 + (6*ScanPhaseShiftA + 1*ScanPhaseShiftB)
  2:243: ScanMag2*1 ScanPhase2 + (6*ScanPhaseShiftA + 2*ScanPhaseShiftB)
  2:244: ScanMag2*1 ScanPhase2 + (6*ScanPhaseShiftA + 3*ScanPhaseShiftB)
  2:245: ScanMag2*1 ScanPhase2 + (6*ScanPhaseShiftA + 4*ScanPhaseShiftB)
  2:246: ScanMag2*1 ScanPhase2 + (6*ScanPhaseShiftA + 5*ScanPhaseShiftB)
  2:247: ScanMag2*1 ScanPhase2 + (6*ScanPhaseShiftA + 6*ScanPhaseShiftB)
  2:248: ScanMag2*1 ScanPhase2 + (6*ScanPhaseShiftA + 7*ScanPhaseShiftB)
  2:249: ScanMag2*1 ScanPhase2 + (6*ScanPhaseShiftA + 8*ScanPhaseShiftB)
  2:250: ScanMag2*1 ScanPhase2 + (6*ScanPhaseShiftA + 9*ScanPhaseShiftB)
  2:251: ScanMag2*1 ScanPhase2 + (6*ScanPhaseShiftA + 10*ScanPhaseShiftB)
  2:252: ScanMag2*1 ScanPhase2 + (6*ScanPhaseShiftA + 11*ScanPhaseShiftB)
  2:253: ScanMag2*1 ScanPhase2 + (6*ScanPhaseShiftA + 12*ScanPhaseShiftB)
  2:254: ScanMag2*1 ScanPhase2 + (6*ScanPhaseShiftA + 13*ScanPhaseShiftB)
  2:255: ScanMag2*1 ScanPhase2 + (6*ScanPhaseShiftA + 14*ScanPhaseShiftB)
  2:256: ScanMag2*1 ScanPhase2 + (6*ScanPhaseShiftA + 15*ScanPhaseShiftB)
  2:257: ScanMag2*1 ScanPhase2 + (6*ScanPhaseShiftA + 16*ScanPhaseShiftB)
  2:258: ScanMag2*1 ScanPhase2 + (6*ScanPhaseShiftA + 17*ScanPhaseShiftB)
  2:259: ScanMag2*1 ScanPhase2 + (6*ScanPhaseShiftA + 18*ScanPhaseShiftB)
  2:260: ScanMag2*1 ScanPhase2 + (6*ScanPhaseShiftA + 19*ScanPhaseShiftB)
  2:261: ScanMag2*1 ScanPhase2 + (6*ScanPhaseShiftA + 20*ScanPhaseShiftB)
  2:262: ScanMag2*1 ScanPhase2 + (6*ScanPhaseShiftA + 21*ScanPhaseShiftB)
  2:263: ScanMag2*1 ScanPhase2 + (6*ScanPhaseShiftA + 22*ScanPhaseShiftB)
  2:264: ScanMag2*1 ScanPhase2 + (6*ScanPhaseShiftA + 23*ScanPhaseShiftB)
  2:265: ScanMag2*1 ScanPhase2 + (6*ScanPhaseShiftA + 24*ScanPhaseShiftB)
  2:266: ScanMag2*1 ScanPhase2 + (6*ScanPhaseShiftA + 25*ScanPhaseShiftB)
  2:267: ScanMag2*1 ScanPhase2 + (6*ScanPhaseShiftA + 26*ScanPhaseShiftB)
  2:268: ScanMag2*1 ScanPhase2 + (6*ScanPhaseShiftA + 27*ScanPhaseShiftB)
  2:269: ScanMag2*1 ScanPhase2 + (6*ScanPhaseShiftA + 28*ScanPhaseShiftB)
  2:270: ScanMag2*1 ScanPhase2 + (6*ScanPhaseShiftA + 29*ScanPhaseShiftB)
  2:271: ScanMag2*1 ScanPhase2 + (6*ScanPhaseShiftA + 30*ScanPhaseShiftB)
  2:272: ScanMag2*1 ScanPhase2 + (6*ScanPhaseShiftA + 31*ScanPhaseShiftB)
  2:273: ScanMag2*1 ScanPhase2 + (6*ScanPhaseShiftA + 32*ScanPhaseShiftB)
  2:274: ScanMag2*1 ScanPhase2 + (6*ScanPhaseShiftA + 33*ScanPhaseShiftB)
  2:275: ScanMag2*1 ScanPhase2 + (6*ScanPhaseShiftA + 34*ScanPhaseShiftB)
  2:276: ScanMag2*1 ScanPhase2 + (6*ScanPhaseShiftA + 35*ScanPhaseShiftB)
  2:277: ScanMag2*1 ScanPhase2 + (6*ScanPhaseShiftA + 36*ScanPhaseShiftB)
  2:278: ScanMag2*1 ScanPhase2 + (6*ScanPhaseShiftA + 37*ScanPhaseShiftB)
  2:279: ScanMag2*1 ScanPhase2 + (6*ScanPhaseShiftA + 38*ScanPhaseShiftB)
  2:280: ScanMag2*1 ScanPhase2 + (6*ScanPhaseShiftA + 39*ScanPhaseShiftB)
  2:281: ScanMag2*1 ScanPhase2 + (7*ScanPhaseShiftA + 0*ScanPhaseShiftB)
  2:282: ScanMag2*1 ScanPhase2 + (7*ScanPhaseShiftA + 1*ScanPhaseShiftB)
  2:283: ScanMag2*1 ScanPhase2 + (7*ScanPhaseShiftA + 2*ScanPhaseShiftB)
  2:284: ScanMag2*1 ScanPhase2 + (7*ScanPhaseShiftA + 3*ScanPhaseShiftB)
  2:285: ScanMag2*1 ScanPhase2 + (7*ScanPhaseShiftA + 4*ScanPhaseShiftB)
  2:286: ScanMag2*1 ScanPhase2 + (7*ScanPhaseShiftA + 5*ScanPhaseShiftB)
  2:287: ScanMag2*1 ScanPhase2 + (7*ScanPhaseShiftA + 6*ScanPhaseShiftB)
  2:288: ScanMag2*1 ScanPhase2 + (7*ScanPhaseShiftA + 7*ScanPhaseShiftB)
  2:289: ScanMag2*1 ScanPhase2 + (7*ScanPhaseShiftA + 8*ScanPhaseShiftB)
  2:290: ScanMag2*1 ScanPhase2 + (7*ScanPhaseShiftA + 9*ScanPhaseShiftB)
  2:291: ScanMag2*1 ScanPhase2 + (7*ScanPhaseShiftA + 10*ScanPhaseShiftB)
  2:292: ScanMag2*1 ScanPhase2 + (7*ScanPhaseShiftA + 11*ScanPhaseShiftB)
  2:293: ScanMag2*1 ScanPhase2 + (7*ScanPhaseShiftA + 12*ScanPhaseShiftB)
  2:294: ScanMag2*1 ScanPhase2 + (7*ScanPhaseShiftA + 13*ScanPhaseShiftB)
  2:295: ScanMag2*1 ScanPhase2 + (7*ScanPhaseShiftA + 14*ScanPhaseShiftB)
  2:296: ScanMag2*1 ScanPhase2 + (7*ScanPhaseShiftA + 15*ScanPhaseShiftB)
  2:297: ScanMag2*1 ScanPhase2 + (7*ScanPhaseShiftA + 16*ScanPhaseShiftB)
  2:298: ScanMag2*1 ScanPhase2 + (7*ScanPhaseShiftA + 17*ScanPhaseShiftB)
  2:299: ScanMag2*1 ScanPhase2 + (7*ScanPhaseShiftA + 18*ScanPhaseShiftB)
  2:300: ScanMag2*1 ScanPhase2 + (7*ScanPhaseShiftA + 19*ScanPhaseShiftB)
  2:301: ScanMag2*1 ScanPhase2 + (7*ScanPhaseShiftA + 20*ScanPhaseShiftB)
  2:302: ScanMag2*1 ScanPhase2 + (7*ScanPhaseShiftA + 21*ScanPhaseShiftB)
  2:303: ScanMag2*1 ScanPhase2 + (7*ScanPhaseShiftA + 22*ScanPhaseShiftB)
  2:304: ScanMag2*1 ScanPhase2 + (7*ScanPhaseShiftA + 23*ScanPhaseShiftB)
  2:305: ScanMag2*1 ScanPhase2 + (7*ScanPhaseShiftA + 24*ScanPhaseShiftB)
  2:306: ScanMag2*1 ScanPhase2 + (7*ScanPhaseShiftA + 25*ScanPhaseShiftB)
  2:307: ScanMag2*1 ScanPhase2 + (7*ScanPhaseShiftA + 26*ScanPhaseShiftB)
  2:308: ScanMag2*1 ScanPhase2 + (7*ScanPhaseShiftA + 27*ScanPhaseShiftB)
  2:309: ScanMag2*1 ScanPhase2 + (7*ScanPhaseShiftA + 28*ScanPhaseShiftB)
  2:310: ScanMag2*1 ScanPhase2 + (7*ScanPhaseShiftA + 29*ScanPhaseShiftB)
  2:311: ScanMag2*1 ScanPhase2 + (7*ScanPhaseShiftA + 30*ScanPhaseShiftB)
  2:312: ScanMag2*1 ScanPhase2 + (7*ScanPhaseShiftA + 31*ScanPhaseShiftB)
  2:313: ScanMag2*1 ScanPhase2 + (7*ScanPhaseShiftA + 32*ScanPhaseShiftB)
  2:314: ScanMag2*1 ScanPhase2 + (7*ScanPhaseShiftA + 33*ScanPhaseShiftB)
  2:315: ScanMag2*1 ScanPhase2 + (7*ScanPhaseShiftA + 34*ScanPhaseShiftB)
  2:316: ScanMag2*1 ScanPhase2 + (7*ScanPhaseShiftA + 35*ScanPhaseShiftB)
  2:317: ScanMag2*1 ScanPhase2 + (7*ScanPhaseShiftA + 36*ScanPhaseShiftB)
  2:318: ScanMag2*1 ScanPhase2 + (7*ScanPhaseShiftA + 37*ScanPhaseShiftB)
  2:319: ScanMag2*1 ScanPhase2 + (7*ScanPhaseShiftA + 38*ScanPhaseShiftB)
  2:320: ScanMag2*1 ScanPhase2 + (7*ScanPhaseShiftA + 39*ScanPhaseShiftB)
  2:321: ScanMag2*1 ScanPhase2 + (8*ScanPhaseShiftA + 0*ScanPhaseShiftB)
  2:322: ScanMag2*1 ScanPhase2 + (8*ScanPhaseShiftA + 1*ScanPhaseShiftB)
  2:323: ScanMag2*1 ScanPhase2 + (8*ScanPhaseShiftA + 2*ScanPhaseShiftB)
  2:324: ScanMag2*1 ScanPhase2 + (8*ScanPhaseShiftA + 3*ScanPhaseShiftB)
  2:325: ScanMag2*1 ScanPhase2 + (8*ScanPhaseShiftA + 4*ScanPhaseShiftB)
  2:326: ScanMag2*1 ScanPhase2 + (8*ScanPhaseShiftA + 5*ScanPhaseShiftB)
  2:327: ScanMag2*1 ScanPhase2 + (8*ScanPhaseShiftA + 6*ScanPhaseShiftB)
  2:328: ScanMag2*1 ScanPhase2 + (8*ScanPhaseShiftA + 7*ScanPhaseShiftB)
  2:329: ScanMag2*1 ScanPhase2 + (8*ScanPhaseShiftA + 8*ScanPhaseShiftB)
  2:330: ScanMag2*1 ScanPhase2 + (8*ScanPhaseShiftA + 9*ScanPhaseShiftB)
  2:331: ScanMag2*1 ScanPhase2 + (8*ScanPhaseShiftA + 10*ScanPhaseShiftB)
  2:332: ScanMag2*1 ScanPhase2 + (8*ScanPhaseShiftA + 11*ScanPhaseShiftB)
  2:333: ScanMag2*1 ScanPhase2 + (8*ScanPhaseShiftA + 12*ScanPhaseShiftB)
  2:334: ScanMag2*1 ScanPhase2 + (8*ScanPhaseShiftA + 13*ScanPhaseShiftB)
  2:335: ScanMag2*1 ScanPhase2 + (8*ScanPhaseShiftA + 14*ScanPhaseShiftB)
  2:336: ScanMag2*1 ScanPhase2 + (8*ScanPhaseShiftA + 15*ScanPhaseShiftB)
  2:337: ScanMag2*1 ScanPhase2 + (8*ScanPhaseShiftA + 16*ScanPhaseShiftB)
  2:338: ScanMag2*1 ScanPhase2 + (8*ScanPhaseShiftA + 17*ScanPhaseShiftB)
  2:339: ScanMag2*1 ScanPhase2 + (8*ScanPhaseShiftA + 18*ScanPhaseShiftB)
  2:340: ScanMag2*1 ScanPhase2 + (8*ScanPhaseShiftA + 19*ScanPhaseShiftB)
  2:341: ScanMag2*1 ScanPhase2 + (8*ScanPhaseShiftA + 20*ScanPhaseShiftB)
  2:342: ScanMag2*1 ScanPhase2 + (8*ScanPhaseShiftA + 21*ScanPhaseShiftB)
  2:343: ScanMag2*1 ScanPhase2 + (8*ScanPhaseShiftA + 22*ScanPhaseShiftB)
  2:344: ScanMag2*1 ScanPhase2 + (8*ScanPhaseShiftA + 23*ScanPhaseShiftB)
  2:345: ScanMag2*1 ScanPhase2 + (8*ScanPhaseShiftA + 24*ScanPhaseShiftB)
  2:346: ScanMag2*1 ScanPhase2 + (8*ScanPhaseShiftA + 25*ScanPhaseShiftB)
  2:347: ScanMag2*1 ScanPhase2 + (8*ScanPhaseShiftA + 26*ScanPhaseShiftB)
  2:348: ScanMag2*1 ScanPhase2 + (8*ScanPhaseShiftA + 27*ScanPhaseShiftB)
  2:349: ScanMag2*1 ScanPhase2 + (8*ScanPhaseShiftA + 28*ScanPhaseShiftB)
  2:350: ScanMag2*1 ScanPhase2 + (8*ScanPhaseShiftA + 29*ScanPhaseShiftB)
  2:351: ScanMag2*1 ScanPhase2 + (8*ScanPhaseShiftA + 30*ScanPhaseShiftB)
  2:352: ScanMag2*1 ScanPhase2 + (8*ScanPhaseShiftA + 31*ScanPhaseShiftB)
  2:353: ScanMag2*1 ScanPhase2 + (8*ScanPhaseShiftA + 32*ScanPhaseShiftB)
  2:354: ScanMag2*1 ScanPhase2 + (8*ScanPhaseShiftA + 33*ScanPhaseShiftB)
  2:355: ScanMag2*1 ScanPhase2 + (8*ScanPhaseShiftA + 34*ScanPhaseShiftB)
  2:356: ScanMag2*1 ScanPhase2 + (8*ScanPhaseShiftA + 35*ScanPhaseShiftB)
  2:357: ScanMag2*1 ScanPhase2 + (8*ScanPhaseShiftA + 36*ScanPhaseShiftB)
  2:358: ScanMag2*1 ScanPhase2 + (8*ScanPhaseShiftA + 37*ScanPhaseShiftB)
  2:359: ScanMag2*1 ScanPhase2 + (8*ScanPhaseShiftA + 38*ScanPhaseShiftB)
  2:360: ScanMag2*1 ScanPhase2 + (8*ScanPhaseShiftA + 39*ScanPhaseShiftB)
  2:361: ScanMag2*1 ScanPhase2 + (9*ScanPhaseShiftA + 0*ScanPhaseShiftB)
  2:362: ScanMag2*1 ScanPhase2 + (9*ScanPhaseShiftA + 1*ScanPhaseShiftB)
  2:363: ScanMag2*1 ScanPhase2 + (9*ScanPhaseShiftA + 2*ScanPhaseShiftB)
  2:364: ScanMag2*1 ScanPhase2 + (9*ScanPhaseShiftA + 3*ScanPhaseShiftB)
  2:365: ScanMag2*1 ScanPhase2 + (9*ScanPhaseShiftA + 4*ScanPhaseShiftB)
  2:366: ScanMag2*1 ScanPhase2 + (9*ScanPhaseShiftA + 5*ScanPhaseShiftB)
  2:367: ScanMag2*1 ScanPhase2 + (9*ScanPhaseShiftA + 6*ScanPhaseShiftB)
  2:368: ScanMag2*1 ScanPhase2 + (9*ScanPhaseShiftA + 7*ScanPhaseShiftB)
  2:369: ScanMag2*1 ScanPhase2 + (9*ScanPhaseShiftA + 8*ScanPhaseShiftB)
  2:370: ScanMag2*1 ScanPhase2 + (9*ScanPhaseShiftA + 9*ScanPhaseShiftB)
  2:371: ScanMag2*1 ScanPhase2 + (9*ScanPhaseShiftA + 10*ScanPhaseShiftB)
  2:372: ScanMag2*1 ScanPhase2 + (9*ScanPhaseShiftA + 11*ScanPhaseShiftB)
  2:373: ScanMag2*1 ScanPhase2 + (9*ScanPhaseShiftA + 12*ScanPhaseShiftB)
  2:374: ScanMag2*1 ScanPhase2 + (9*ScanPhaseShiftA + 13*ScanPhaseShiftB)
  2:375: ScanMag2*1 ScanPhase2 + (9*ScanPhaseShiftA + 14*ScanPhaseShiftB)
  2:376: ScanMag2*1 ScanPhase2 + (9*ScanPhaseShiftA + 15*ScanPhaseShiftB)
  2:377: ScanMag2*1 ScanPhase2 + (9*ScanPhaseShiftA + 16*ScanPhaseShiftB)
  2:378: ScanMag2*1 ScanPhase2 + (9*ScanPhaseShiftA + 17*ScanPhaseShiftB)
  2:379: ScanMag2*1 ScanPhase2 + (9*ScanPhaseShiftA + 18*ScanPhaseShiftB)
  2:380: ScanMag2*1 ScanPhase2 + (9*ScanPhaseShiftA + 19*ScanPhaseShiftB)
  2:381: ScanMag2*1 ScanPhase2 + (9*ScanPhaseShiftA + 20*ScanPhaseShiftB)
  2:382: ScanMag2*1 ScanPhase2 + (9*ScanPhaseShiftA + 21*ScanPhaseShiftB)
  2:383: ScanMag2*1 ScanPhase2 + (9*ScanPhaseShiftA + 22*ScanPhaseShiftB)
  2:384: ScanMag2*1 ScanPhase2 + (9*ScanPhaseShiftA + 23*ScanPhaseShiftB)
  2:385: ScanMag2*1 ScanPhase2 + (9*ScanPhaseShiftA + 24*ScanPhaseShiftB)
  2:386: ScanMag2*1 ScanPhase2 + (9*ScanPhaseShiftA + 25*ScanPhaseShiftB)
  2:387: ScanMag2*1 ScanPhase2 + (9*ScanPhaseShiftA + 26*ScanPhaseShiftB)
  2:388: ScanMag2*1 ScanPhase2 + (9*ScanPhaseShiftA + 27*ScanPhaseShiftB)
  2:389: ScanMag2*1 ScanPhase2 + (9*ScanPhaseShiftA + 28*ScanPhaseShiftB)
  2:390: ScanMag2*1 ScanPhase2 + (9*ScanPhaseShiftA + 29*ScanPhaseShiftB)
  2:391: ScanMag2*1 ScanPhase2 + (9*ScanPhaseShiftA + 30*ScanPhaseShiftB)
  2:392: ScanMag2*1 ScanPhase2 + (9*ScanPhaseShiftA + 31*ScanPhaseShiftB)
  2:393: ScanMag2*1 ScanPhase2 + (9*ScanPhaseShiftA + 32*ScanPhaseShiftB)
  2:394: ScanMag2*1 ScanPhase2 + (9*ScanPhaseShiftA + 33*ScanPhaseShiftB)
  2:395: ScanMag2*1 ScanPhase2 + (9*ScanPhaseShiftA + 34*ScanPhaseShiftB)
  2:396: ScanMag2*1 ScanPhase2 + (9*ScanPhaseShiftA + 35*ScanPhaseShiftB)
  2:397: ScanMag2*1 ScanPhase2 + (9*ScanPhaseShiftA + 36*ScanPhaseShiftB)
  2:398: ScanMag2*1 ScanPhase2 + (9*ScanPhaseShiftA + 37*ScanPhaseShiftB)
  2:399: ScanMag2*1 ScanPhase2 + (9*ScanPhaseShiftA + 38*ScanPhaseShiftB)
  2:400: ScanMag2*1 ScanPhase2 + (9*ScanPhaseShiftA + 39*ScanPhaseShiftB)
  2:401: ScanMag2*1 ScanPhase2 + (10*ScanPhaseShiftA + 0*ScanPhaseShiftB)
  2:402: ScanMag2*1 ScanPhase2 + (10*ScanPhaseShiftA + 1*ScanPhaseShiftB)
  2:403: ScanMag2*1 ScanPhase2 + (10*ScanPhaseShiftA + 2*ScanPhaseShiftB)
  2:404: ScanMag2*1 ScanPhase2 + (10*ScanPhaseShiftA + 3*ScanPhaseShiftB)
  2:405: ScanMag2*1 ScanPhase2 + (10*ScanPhaseShiftA + 4*ScanPhaseShiftB)
  2:406: ScanMag2*1 ScanPhase2 + (10*ScanPhaseShiftA + 5*ScanPhaseShiftB)
  2:407: ScanMag2*1 ScanPhase2 + (10*ScanPhaseShiftA + 6*ScanPhaseShiftB)
  2:408: ScanMag2*1 ScanPhase2 + (10*ScanPhaseShiftA + 7*ScanPhaseShiftB)
  2:409: ScanMag2*1 ScanPhase2 + (10*ScanPhaseShiftA + 8*ScanPhaseShiftB)
  2:410: ScanMag2*1 ScanPhase2 + (10*ScanPhaseShiftA + 9*ScanPhaseShiftB)
  2:411: ScanMag2*1 ScanPhase2 + (10*ScanPhaseShiftA + 10*ScanPhaseShiftB)
  2:412: ScanMag2*1 ScanPhase2 + (10*ScanPhaseShiftA + 11*ScanPhaseShiftB)
  2:413: ScanMag2*1 ScanPhase2 + (10*ScanPhaseShiftA + 12*ScanPhaseShiftB)
  2:414: ScanMag2*1 ScanPhase2 + (10*ScanPhaseShiftA + 13*ScanPhaseShiftB)
  2:415: ScanMag2*1 ScanPhase2 + (10*ScanPhaseShiftA + 14*ScanPhaseShiftB)
  2:416: ScanMag2*1 ScanPhase2 + (10*ScanPhaseShiftA + 15*ScanPhaseShiftB)
  2:417: ScanMag2*1 ScanPhase2 + (10*ScanPhaseShiftA + 16*ScanPhaseShiftB)
  2:418: ScanMag2*1 ScanPhase2 + (10*ScanPhaseShiftA + 17*ScanPhaseShiftB)
  2:419: ScanMag2*1 ScanPhase2 + (10*ScanPhaseShiftA + 18*ScanPhaseShiftB)
  2:420: ScanMag2*1 ScanPhase2 + (10*ScanPhaseShiftA + 19*ScanPhaseShiftB)
  2:421: ScanMag2*1 ScanPhase2 + (10*ScanPhaseShiftA + 20*ScanPhaseShiftB)
  2:422: ScanMag2*1 ScanPhase2 + (10*ScanPhaseShiftA + 21*ScanPhaseShiftB)
  2:423: ScanMag2*1 ScanPhase2 + (10*ScanPhaseShiftA + 22*ScanPhaseShiftB)
  2:424: ScanMag2*1 ScanPhase2 + (10*ScanPhaseShiftA + 23*ScanPhaseShiftB)
  2:425: ScanMag2*1 ScanPhase2 + (10*ScanPhaseShiftA + 24*ScanPhaseShiftB)
  2:426: ScanMag2*1 ScanPhase2 + (10*ScanPhaseShiftA + 25*ScanPhaseShiftB)
  2:427: ScanMag2*1 ScanPhase2 + (10*ScanPhaseShiftA + 26*ScanPhaseShiftB)
  2:428: ScanMag2*1 ScanPhase2 + (10*ScanPhaseShiftA + 27*ScanPhaseShiftB)
  2:429: ScanMag2*1 ScanPhase2 + (10*ScanPhaseShiftA + 28*ScanPhaseShiftB)
  2:430: ScanMag2*1 ScanPhase2 + (10*ScanPhaseShiftA + 29*ScanPhaseShiftB)
  2:431: ScanMag2*1 ScanPhase2 + (10*ScanPhaseShiftA + 30*ScanPhaseShiftB)
  2:432: ScanMag2*1 ScanPhase2 + (10*ScanPhaseShiftA + 31*ScanPhaseShiftB)
  2:433: ScanMag2*1 ScanPhase2 + (10*ScanPhaseShiftA + 32*ScanPhaseShiftB)
  2:434: ScanMag2*1 ScanPhase2 + (10*ScanPhaseShiftA + 33*ScanPhaseShiftB)
  2:435: ScanMag2*1 ScanPhase2 + (10*ScanPhaseShiftA + 34*ScanPhaseShiftB)
  2:436: ScanMag2*1 ScanPhase2 + (10*ScanPhaseShiftA + 35*ScanPhaseShiftB)
  2:437: ScanMag2*1 ScanPhase2 + (10*ScanPhaseShiftA + 36*ScanPhaseShiftB)
  2:438: ScanMag2*1 ScanPhase2 + (10*ScanPhaseShiftA + 37*ScanPhaseShiftB)
  2:439: ScanMag2*1 ScanPhase2 + (10*ScanPhaseShiftA + 38*ScanPhaseShiftB)
  2:440: ScanMag2*1 ScanPhase2 + (10*ScanPhaseShiftA + 39*ScanPhaseShiftB)
  2:441: ScanMag2*1 ScanPhase2 + (11*ScanPhaseShiftA + 0*ScanPhaseShiftB)
  2:442: ScanMag2*1 ScanPhase2 + (11*ScanPhaseShiftA + 1*ScanPhaseShiftB)
  2:443: ScanMag2*1 ScanPhase2 + (11*ScanPhaseShiftA + 2*ScanPhaseShiftB)
  2:444: ScanMag2*1 ScanPhase2 + (11*ScanPhaseShiftA + 3*ScanPhaseShiftB)
  2:445: ScanMag2*1 ScanPhase2 + (11*ScanPhaseShiftA + 4*ScanPhaseShiftB)
  2:446: ScanMag2*1 ScanPhase2 + (11*ScanPhaseShiftA + 5*ScanPhaseShiftB)
  2:447: ScanMag2*1 ScanPhase2 + (11*ScanPhaseShiftA + 6*ScanPhaseShiftB)
  2:448: ScanMag2*1 ScanPhase2 + (11*ScanPhaseShiftA + 7*ScanPhaseShiftB)
  2:449: ScanMag2*1 ScanPhase2 + (11*ScanPhaseShiftA + 8*ScanPhaseShiftB)
  2:450: ScanMag2*1 ScanPhase2 + (11*ScanPhaseShiftA + 9*ScanPhaseShiftB)
  2:451: ScanMag2*1 ScanPhase2 + (11*ScanPhaseShiftA + 10*ScanPhaseShiftB)
  2:452: ScanMag2*1 ScanPhase2 + (11*ScanPhaseShiftA + 11*ScanPhaseShiftB)
  2:453: ScanMag2*1 ScanPhase2 + (11*ScanPhaseShiftA + 12*ScanPhaseShiftB)
  2:454: ScanMag2*1 ScanPhase2 + (11*ScanPhaseShiftA + 13*ScanPhaseShiftB)
  2:455: ScanMag2*1 ScanPhase2 + (11*ScanPhaseShiftA + 14*ScanPhaseShiftB)
  2:456: ScanMag2*1 ScanPhase2 + (11*ScanPhaseShiftA + 15*ScanPhaseShiftB)
  2:457: ScanMag2*1 ScanPhase2 + (11*ScanPhaseShiftA + 16*ScanPhaseShiftB)
  2:458: ScanMag2*1 ScanPhase2 + (11*ScanPhaseShiftA + 17*ScanPhaseShiftB)
  2:459: ScanMag2*1 ScanPhase2 + (11*ScanPhaseShiftA + 18*ScanPhaseShiftB)
  2:460: ScanMag2*1 ScanPhase2 + (11*ScanPhaseShiftA + 19*ScanPhaseShiftB)
  2:461: ScanMag2*1 ScanPhase2 + (11*ScanPhaseShiftA + 20*ScanPhaseShiftB)
  2:462: ScanMag2*1 ScanPhase2 + (11*ScanPhaseShiftA + 21*ScanPhaseShiftB)
  2:463: ScanMag2*1 ScanPhase2 + (11*ScanPhaseShiftA + 22*ScanPhaseShiftB)
  2:464: ScanMag2*1 ScanPhase2 + (11*ScanPhaseShiftA + 23*ScanPhaseShiftB)
  2:465: ScanMag2*1 ScanPhase2 + (11*ScanPhaseShiftA + 24*ScanPhaseShiftB)
  2:466: ScanMag2*1 ScanPhase2 + (11*ScanPhaseShiftA + 25*ScanPhaseShiftB)
  2:467: ScanMag2*1 ScanPhase2 + (11*ScanPhaseShiftA + 26*ScanPhaseShiftB)
  2:468: ScanMag2*1 ScanPhase2 + (11*ScanPhaseShiftA + 27*ScanPhaseShiftB)
  2:469: ScanMag2*1 ScanPhase2 + (11*ScanPhaseShiftA + 28*ScanPhaseShiftB)
  2:470: ScanMag2*1 ScanPhase2 + (11*ScanPhaseShiftA + 29*ScanPhaseShiftB)
  2:471: ScanMag2*1 ScanPhase2 + (11*ScanPhaseShiftA + 30*ScanPhaseShiftB)
  2:472: ScanMag2*1 ScanPhase2 + (11*ScanPhaseShiftA + 31*ScanPhaseShiftB)
  2:473: ScanMag2*1 ScanPhase2 + (11*ScanPhaseShiftA + 32*ScanPhaseShiftB)
  2:474: ScanMag2*1 ScanPhase2 + (11*ScanPhaseShiftA + 33*ScanPhaseShiftB)
  2:475: ScanMag2*1 ScanPhase2 + (11*ScanPhaseShiftA + 34*ScanPhaseShiftB)
  2:476: ScanMag2*1 ScanPhase2 + (11*ScanPhaseShiftA + 35*ScanPhaseShiftB)
  2:477: ScanMag2*1 ScanPhase2 + (11*ScanPhaseShiftA + 36*ScanPhaseShiftB)
  2:478: ScanMag2*1 ScanPhase2 + (11*ScanPhaseShiftA + 37*ScanPhaseShiftB)
  2:479: ScanMag2*1 ScanPhase2 + (11*ScanPhaseShiftA + 38*ScanPhaseShiftB)
  2:480: ScanMag2*1 ScanPhase2 + (11*ScanPhaseShiftA + 39*ScanPhaseShiftB)
  2:481: ScanMag2*1 ScanPhase2 + (12*ScanPhaseShiftA + 0*ScanPhaseShiftB)
  2:482: ScanMag2*1 ScanPhase2 + (12*ScanPhaseShiftA + 1*ScanPhaseShiftB)
  2:483: ScanMag2*1 ScanPhase2 + (12*ScanPhaseShiftA + 2*ScanPhaseShiftB)
  2:484: ScanMag2*1 ScanPhase2 + (12*ScanPhaseShiftA + 3*ScanPhaseShiftB)
  2:485: ScanMag2*1 ScanPhase2 + (12*ScanPhaseShiftA + 4*ScanPhaseShiftB)
  2:486: ScanMag2*1 ScanPhase2 + (12*ScanPhaseShiftA + 5*ScanPhaseShiftB)
  2:487: ScanMag2*1 ScanPhase2 + (12*ScanPhaseShiftA + 6*ScanPhaseShiftB)
  2:488: ScanMag2*1 ScanPhase2 + (12*ScanPhaseShiftA + 7*ScanPhaseShiftB)
  2:489: ScanMag2*1 ScanPhase2 + (12*ScanPhaseShiftA + 8*ScanPhaseShiftB)
  2:490: ScanMag2*1 ScanPhase2 + (12*ScanPhaseShiftA + 9*ScanPhaseShiftB)
  2:491: ScanMag2*1 ScanPhase2 + (12*ScanPhaseShiftA + 10*ScanPhaseShiftB)
  2:492: ScanMag2*1 ScanPhase2 + (12*ScanPhaseShiftA + 11*ScanPhaseShiftB)
  2:493: ScanMag2*1 ScanPhase2 + (12*ScanPhaseShiftA + 12*ScanPhaseShiftB)
  2:494: ScanMag2*1 ScanPhase2 + (12*ScanPhaseShiftA + 13*ScanPhaseShiftB)
  2:495: ScanMag2*1 ScanPhase2 + (12*ScanPhaseShiftA + 14*ScanPhaseShiftB)
  2:496: ScanMag2*1 ScanPhase2 + (12*ScanPhaseShiftA + 15*ScanPhaseShiftB)
  2:497: ScanMag2*1 ScanPhase2 + (12*ScanPhaseShiftA + 16*ScanPhaseShiftB)
  2:498: ScanMag2*1 ScanPhase2 + (12*ScanPhaseShiftA + 17*ScanPhaseShiftB)
  2:499: ScanMag2*1 ScanPhase2 + (12*ScanPhaseShiftA + 18*ScanPhaseShiftB)
  2:500: ScanMag2*1 ScanPhase2 + (12*ScanPhaseShiftA + 19*ScanPhaseShiftB)
  2:501: ScanMag2*1 ScanPhase2 + (12*ScanPhaseShiftA + 20*ScanPhaseShiftB)
  2:502: ScanMag2*1 ScanPhase2 + (12*ScanPhaseShiftA + 21*ScanPhaseShiftB)
  2:503: ScanMag2*1 ScanPhase2 + (12*ScanPhaseShiftA + 22*ScanPhaseShiftB)
  2:504: ScanMag2*1 ScanPhase2 + (12*ScanPhaseShiftA + 23*ScanPhaseShiftB)
  2:505: ScanMag2*1 ScanPhase2 + (12*ScanPhaseShiftA + 24*ScanPhaseShiftB)
  2:506: ScanMag2*1 ScanPhase2 + (12*ScanPhaseShiftA + 25*ScanPhaseShiftB)
  2:507: ScanMag2*1 ScanPhase2 + (12*ScanPhaseShiftA + 26*ScanPhaseShiftB)
  2:508: ScanMag2*1 ScanPhase2 + (12*ScanPhaseShiftA + 27*ScanPhaseShiftB)
  2:509: ScanMag2*1 ScanPhase2 + (12*ScanPhaseShiftA + 28*ScanPhaseShiftB)
  2:510: ScanMag2*1 ScanPhase2 + (12*ScanPhaseShiftA + 29*ScanPhaseShiftB)
  2:511: ScanMag2*1 ScanPhase2 + (12*ScanPhaseShiftA + 30*ScanPhaseShiftB)
  2:512: ScanMag2*1 ScanPhase2 + (12*ScanPhaseShiftA + 31*ScanPhaseShiftB)
  2:513: ScanMag2*1 ScanPhase2 + (12*ScanPhaseShiftA + 32*ScanPhaseShiftB)
  2:514: ScanMag2*1 ScanPhase2 + (12*ScanPhaseShiftA + 33*ScanPhaseShiftB)
  2:515: ScanMag2*1 ScanPhase2 + (12*ScanPhaseShiftA + 34*ScanPhaseShiftB)
  2:516: ScanMag2*1 ScanPhase2 + (12*ScanPhaseShiftA + 35*ScanPhaseShiftB)
  2:517: ScanMag2*1 ScanPhase2 + (12*ScanPhaseShiftA + 36*ScanPhaseShiftB)
  2:518: ScanMag2*1 ScanPhase2 + (12*ScanPhaseShiftA + 37*ScanPhaseShiftB)
  2:519: ScanMag2*1 ScanPhase2 + (12*ScanPhaseShiftA + 38*ScanPhaseShiftB)
  2:520: ScanMag2*1 ScanPhase2 + (12*ScanPhaseShiftA + 39*ScanPhaseShiftB)
  2:521: ScanMag2*1 ScanPhase2 + (13*ScanPhaseShiftA + 0*ScanPhaseShiftB)
  2:522: ScanMag2*1 ScanPhase2 + (13*ScanPhaseShiftA + 1*ScanPhaseShiftB)
  2:523: ScanMag2*1 ScanPhase2 + (13*ScanPhaseShiftA + 2*ScanPhaseShiftB)
  2:524: ScanMag2*1 ScanPhase2 + (13*ScanPhaseShiftA + 3*ScanPhaseShiftB)
  2:525: ScanMag2*1 ScanPhase2 + (13*ScanPhaseShiftA + 4*ScanPhaseShiftB)
  2:526: ScanMag2*1 ScanPhase2 + (13*ScanPhaseShiftA + 5*ScanPhaseShiftB)
  2:527: ScanMag2*1 ScanPhase2 + (13*ScanPhaseShiftA + 6*ScanPhaseShiftB)
  2:528: ScanMag2*1 ScanPhase2 + (13*ScanPhaseShiftA + 7*ScanPhaseShiftB)
  2:529: ScanMag2*1 ScanPhase2 + (13*ScanPhaseShiftA + 8*ScanPhaseShiftB)
  2:530: ScanMag2*1 ScanPhase2 + (13*ScanPhaseShiftA + 9*ScanPhaseShiftB)
  2:531: ScanMag2*1 ScanPhase2 + (13*ScanPhaseShiftA + 10*ScanPhaseShiftB)
  2:532: ScanMag2*1 ScanPhase2 + (13*ScanPhaseShiftA + 11*ScanPhaseShiftB)
  2:533: ScanMag2*1 ScanPhase2 + (13*ScanPhaseShiftA + 12*ScanPhaseShiftB)
  2:534: ScanMag2*1 ScanPhase2 + (13*ScanPhaseShiftA + 13*ScanPhaseShiftB)
  2:535: ScanMag2*1 ScanPhase2 + (13*ScanPhaseShiftA + 14*ScanPhaseShiftB)
  2:536: ScanMag2*1 ScanPhase2 + (13*ScanPhaseShiftA + 15*ScanPhaseShiftB)
  2:537: ScanMag2*1 ScanPhase2 + (13*ScanPhaseShiftA + 16*ScanPhaseShiftB)
  2:538: ScanMag2*1 ScanPhase2 + (13*ScanPhaseShiftA + 17*ScanPhaseShiftB)
  2:539: ScanMag2*1 ScanPhase2 + (13*ScanPhaseShiftA + 18*ScanPhaseShiftB)
  2:540: ScanMag2*1 ScanPhase2 + (13*ScanPhaseShiftA + 19*ScanPhaseShiftB)
  2:541: ScanMag2*1 ScanPhase2 + (13*ScanPhaseShiftA + 20*ScanPhaseShiftB)
  2:542: ScanMag2*1 ScanPhase2 + (13*ScanPhaseShiftA + 21*ScanPhaseShiftB)
  2:543: ScanMag2*1 ScanPhase2 + (13*ScanPhaseShiftA + 22*ScanPhaseShiftB)
  2:544: ScanMag2*1 ScanPhase2 + (13*ScanPhaseShiftA + 23*ScanPhaseShiftB)
  2:545: ScanMag2*1 ScanPhase2 + (13*ScanPhaseShiftA + 24*ScanPhaseShiftB)
  2:546: ScanMag2*1 ScanPhase2 + (13*ScanPhaseShiftA + 25*ScanPhaseShiftB)
  2:547: ScanMag2*1 ScanPhase2 + (13*ScanPhaseShiftA + 26*ScanPhaseShiftB)
  2:548: ScanMag2*1 ScanPhase2 + (13*ScanPhaseShiftA + 27*ScanPhaseShiftB)
  2:549: ScanMag2*1 ScanPhase2 + (13*ScanPhaseShiftA + 28*ScanPhaseShiftB)
  2:550: ScanMag2*1 ScanPhase2 + (13*ScanPhaseShiftA + 29*ScanPhaseShiftB)
  2:551: ScanMag2*1 ScanPhase2 + (13*ScanPhaseShiftA + 30*ScanPhaseShiftB)
  2:552: ScanMag2*1 ScanPhase2 + (13*ScanPhaseShiftA + 31*ScanPhaseShiftB)
  2:553: ScanMag2*1 ScanPhase2 + (13*ScanPhaseShiftA + 32*ScanPhaseShiftB)
  2:554: ScanMag2*1 ScanPhase2 + (13*ScanPhaseShiftA + 33*ScanPhaseShiftB)
  2:555: ScanMag2*1 ScanPhase2 + (13*ScanPhaseShiftA + 34*ScanPhaseShiftB)
  2:556: ScanMag2*1 ScanPhase2 + (13*ScanPhaseShiftA + 35*ScanPhaseShiftB)
  2:557: ScanMag2*1 ScanPhase2 + (13*ScanPhaseShiftA + 36*ScanPhaseShiftB)
  2:558: ScanMag2*1 ScanPhase2 + (13*ScanPhaseShiftA + 37*ScanPhaseShiftB)
  2:559: ScanMag2*1 ScanPhase2 + (13*ScanPhaseShiftA + 38*ScanPhaseShiftB)
  2:560: ScanMag2*1 ScanPhase2 + (13*ScanPhaseShiftA + 39*ScanPhaseShiftB)
  2:561: ScanMag2*1 ScanPhase2 + (14*ScanPhaseShiftA + 0*ScanPhaseShiftB)
  2:562: ScanMag2*1 ScanPhase2 + (14*ScanPhaseShiftA + 1*ScanPhaseShiftB)
  2:563: ScanMag2*1 ScanPhase2 + (14*ScanPhaseShiftA + 2*ScanPhaseShiftB)
  2:564: ScanMag2*1 ScanPhase2 + (14*ScanPhaseShiftA + 3*ScanPhaseShiftB)
  2:565: ScanMag2*1 ScanPhase2 + (14*ScanPhaseShiftA + 4*ScanPhaseShiftB)
  2:566: ScanMag2*1 ScanPhase2 + (14*ScanPhaseShiftA + 5*ScanPhaseShiftB)
  2:567: ScanMag2*1 ScanPhase2 + (14*ScanPhaseShiftA + 6*ScanPhaseShiftB)
  2:568: ScanMag2*1 ScanPhase2 + (14*ScanPhaseShiftA + 7*ScanPhaseShiftB)
  2:569: ScanMag2*1 ScanPhase2 + (14*ScanPhaseShiftA + 8*ScanPhaseShiftB)
  2:570: ScanMag2*1 ScanPhase2 + (14*ScanPhaseShiftA + 9*ScanPhaseShiftB)
  2:571: ScanMag2*1 ScanPhase2 + (14*ScanPhaseShiftA + 10*ScanPhaseShiftB)
  2:572: ScanMag2*1 ScanPhase2 + (14*ScanPhaseShiftA + 11*ScanPhaseShiftB)
  2:573: ScanMag2*1 ScanPhase2 + (14*ScanPhaseShiftA + 12*ScanPhaseShiftB)
  2:574: ScanMag2*1 ScanPhase2 + (14*ScanPhaseShiftA + 13*ScanPhaseShiftB)
  2:575: ScanMag2*1 ScanPhase2 + (14*ScanPhaseShiftA + 14*ScanPhaseShiftB)
  2:576: ScanMag2*1 ScanPhase2 + (14*ScanPhaseShiftA + 15*ScanPhaseShiftB)
  2:577: ScanMag2*1 ScanPhase2 + (14*ScanPhaseShiftA + 16*ScanPhaseShiftB)
  2:578: ScanMag2*1 ScanPhase2 + (14*ScanPhaseShiftA + 17*ScanPhaseShiftB)
  2:579: ScanMag2*1 ScanPhase2 + (14*ScanPhaseShiftA + 18*ScanPhaseShiftB)
  2:580: ScanMag2*1 ScanPhase2 + (14*ScanPhaseShiftA + 19*ScanPhaseShiftB)
  2:581: ScanMag2*1 ScanPhase2 + (14*ScanPhaseShiftA + 20*ScanPhaseShiftB)
  2:582: ScanMag2*1 ScanPhase2 + (14*ScanPhaseShiftA + 21*ScanPhaseShiftB)
  2:583: ScanMag2*1 ScanPhase2 + (14*ScanPhaseShiftA + 22*ScanPhaseShiftB)
  2:584: ScanMag2*1 ScanPhase2 + (14*ScanPhaseShiftA + 23*ScanPhaseShiftB)
  2:585: ScanMag2*1 ScanPhase2 + (14*ScanPhaseShiftA + 24*ScanPhaseShiftB)
  2:586: ScanMag2*1 ScanPhase2 + (14*ScanPhaseShiftA + 25*ScanPhaseShiftB)
  2:587: ScanMag2*1 ScanPhase2 + (14*ScanPhaseShiftA + 26*ScanPhaseShiftB)
  2:588: ScanMag2*1 ScanPhase2 + (14*ScanPhaseShiftA + 27*ScanPhaseShiftB)
  2:589: ScanMag2*1 ScanPhase2 + (14*ScanPhaseShiftA + 28*ScanPhaseShiftB)
  2:590: ScanMag2*1 ScanPhase2 + (14*ScanPhaseShiftA + 29*ScanPhaseShiftB)
  2:591: ScanMag2*1 ScanPhase2 + (14*ScanPhaseShiftA + 30*ScanPhaseShiftB)
  2:592: ScanMag2*1 ScanPhase2 + (14*ScanPhaseShiftA + 31*ScanPhaseShiftB)
  2:593: ScanMag2*1 ScanPhase2 + (14*ScanPhaseShiftA + 32*ScanPhaseShiftB)
  2:594: ScanMag2*1 ScanPhase2 + (14*ScanPhaseShiftA + 33*ScanPhaseShiftB)
  2:595: ScanMag2*1 ScanPhase2 + (14*ScanPhaseShiftA + 34*ScanPhaseShiftB)
  2:596: ScanMag2*1 ScanPhase2 + (14*ScanPhaseShiftA + 35*ScanPhaseShiftB)
  2:597: ScanMag2*1 ScanPhase2 + (14*ScanPhaseShiftA + 36*ScanPhaseShiftB)
  2:598: ScanMag2*1 ScanPhase2 + (14*ScanPhaseShiftA + 37*ScanPhaseShiftB)
  2:599: ScanMag2*1 ScanPhase2 + (14*ScanPhaseShiftA + 38*ScanPhaseShiftB)
  2:600: ScanMag2*1 ScanPhase2 + (14*ScanPhaseShiftA + 39*ScanPhaseShiftB)
  2:601: ScanMag2*1 ScanPhase2 + (15*ScanPhaseShiftA + 0*ScanPhaseShiftB)
  2:602: ScanMag2*1 ScanPhase2 + (15*ScanPhaseShiftA + 1*ScanPhaseShiftB)
  2:603: ScanMag2*1 ScanPhase2 + (15*ScanPhaseShiftA + 2*ScanPhaseShiftB)
  2:604: ScanMag2*1 ScanPhase2 + (15*ScanPhaseShiftA + 3*ScanPhaseShiftB)
  2:605: ScanMag2*1 ScanPhase2 + (15*ScanPhaseShiftA + 4*ScanPhaseShiftB)
  2:606: ScanMag2*1 ScanPhase2 + (15*ScanPhaseShiftA + 5*ScanPhaseShiftB)
  2:607: ScanMag2*1 ScanPhase2 + (15*ScanPhaseShiftA + 6*ScanPhaseShiftB)
  2:608: ScanMag2*1 ScanPhase2 + (15*ScanPhaseShiftA + 7*ScanPhaseShiftB)
  2:609: ScanMag2*1 ScanPhase2 + (15*ScanPhaseShiftA + 8*ScanPhaseShiftB)
  2:610: ScanMag2*1 ScanPhase2 + (15*ScanPhaseShiftA + 9*ScanPhaseShiftB)
  2:611: ScanMag2*1 ScanPhase2 + (15*ScanPhaseShiftA + 10*ScanPhaseShiftB)
  2:612: ScanMag2*1 ScanPhase2 + (15*ScanPhaseShiftA + 11*ScanPhaseShiftB)
  2:613: ScanMag2*1 ScanPhase2 + (15*ScanPhaseShiftA + 12*ScanPhaseShiftB)
  2:614: ScanMag2*1 ScanPhase2 + (15*ScanPhaseShiftA + 13*ScanPhaseShiftB)
  2:615: ScanMag2*1 ScanPhase2 + (15*ScanPhaseShiftA + 14*ScanPhaseShiftB)
  2:616: ScanMag2*1 ScanPhase2 + (15*ScanPhaseShiftA + 15*ScanPhaseShiftB)
  2:617: ScanMag2*1 ScanPhase2 + (15*ScanPhaseShiftA + 16*ScanPhaseShiftB)
  2:618: ScanMag2*1 ScanPhase2 + (15*ScanPhaseShiftA + 17*ScanPhaseShiftB)
  2:619: ScanMag2*1 ScanPhase2 + (15*ScanPhaseShiftA + 18*ScanPhaseShiftB)
  2:620: ScanMag2*1 ScanPhase2 + (15*ScanPhaseShiftA + 19*ScanPhaseShiftB)
  2:621: ScanMag2*1 ScanPhase2 + (15*ScanPhaseShiftA + 20*ScanPhaseShiftB)
  2:622: ScanMag2*1 ScanPhase2 + (15*ScanPhaseShiftA + 21*ScanPhaseShiftB)
  2:623: ScanMag2*1 ScanPhase2 + (15*ScanPhaseShiftA + 22*ScanPhaseShiftB)
  2:624: ScanMag2*1 ScanPhase2 + (15*ScanPhaseShiftA + 23*ScanPhaseShiftB)
  2:625: ScanMag2*1 ScanPhase2 + (15*ScanPhaseShiftA + 24*ScanPhaseShiftB)
  2:626: ScanMag2*1 ScanPhase2 + (15*ScanPhaseShiftA + 25*ScanPhaseShiftB)
  2:627: ScanMag2*1 ScanPhase2 + (15*ScanPhaseShiftA + 26*ScanPhaseShiftB)
  2:628: ScanMag2*1 ScanPhase2 + (15*ScanPhaseShiftA + 27*ScanPhaseShiftB)
  2:629: ScanMag2*1 ScanPhase2 + (15*ScanPhaseShiftA + 28*ScanPhaseShiftB)
  2:630: ScanMag2*1 ScanPhase2 + (15*ScanPhaseShiftA + 29*ScanPhaseShiftB)
  2:631: ScanMag2*1 ScanPhase2 + (15*ScanPhaseShiftA + 30*ScanPhaseShiftB)
  2:632: ScanMag2*1 ScanPhase2 + (15*ScanPhaseShiftA + 31*ScanPhaseShiftB)
  2:633: ScanMag2*1 ScanPhase2 + (15*ScanPhaseShiftA + 32*ScanPhaseShiftB)
  2:634: ScanMag2*1 ScanPhase2 + (15*ScanPhaseShiftA + 33*ScanPhaseShiftB)
  2:635: ScanMag2*1 ScanPhase2 + (15*ScanPhaseShiftA + 34*ScanPhaseShiftB)
  2:636: ScanMag2*1 ScanPhase2 + (15*ScanPhaseShiftA + 35*ScanPhaseShiftB)
  2:637: ScanMag2*1 ScanPhase2 + (15*ScanPhaseShiftA + 36*ScanPhaseShiftB)
  2:638: ScanMag2*1 ScanPhase2 + (15*ScanPhaseShiftA + 37*ScanPhaseShiftB)
  2:639: ScanMag2*1 ScanPhase2 + (15*ScanPhaseShiftA + 38*ScanPhaseShiftB)
  2:640: ScanMag2*1 ScanPhase2 + (15*ScanPhaseShiftA + 39*ScanPhaseShiftB)
  2:641: ScanMag2*1 ScanPhase2 + (16*ScanPhaseShiftA + 0*ScanPhaseShiftB)
  2:642: ScanMag2*1 ScanPhase2 + (16*ScanPhaseShiftA + 1*ScanPhaseShiftB)
  2:643: ScanMag2*1 ScanPhase2 + (16*ScanPhaseShiftA + 2*ScanPhaseShiftB)
  2:644: ScanMag2*1 ScanPhase2 + (16*ScanPhaseShiftA + 3*ScanPhaseShiftB)
  2:645: ScanMag2*1 ScanPhase2 + (16*ScanPhaseShiftA + 4*ScanPhaseShiftB)
  2:646: ScanMag2*1 ScanPhase2 + (16*ScanPhaseShiftA + 5*ScanPhaseShiftB)
  2:647: ScanMag2*1 ScanPhase2 + (16*ScanPhaseShiftA + 6*ScanPhaseShiftB)
  2:648: ScanMag2*1 ScanPhase2 + (16*ScanPhaseShiftA + 7*ScanPhaseShiftB)
  2:649: ScanMag2*1 ScanPhase2 + (16*ScanPhaseShiftA + 8*ScanPhaseShiftB)
  2:650: ScanMag2*1 ScanPhase2 + (16*ScanPhaseShiftA + 9*ScanPhaseShiftB)
  2:651: ScanMag2*1 ScanPhase2 + (16*ScanPhaseShiftA + 10*ScanPhaseShiftB)
  2:652: ScanMag2*1 ScanPhase2 + (16*ScanPhaseShiftA + 11*ScanPhaseShiftB)
  2:653: ScanMag2*1 ScanPhase2 + (16*ScanPhaseShiftA + 12*ScanPhaseShiftB)
  2:654: ScanMag2*1 ScanPhase2 + (16*ScanPhaseShiftA + 13*ScanPhaseShiftB)
  2:655: ScanMag2*1 ScanPhase2 + (16*ScanPhaseShiftA + 14*ScanPhaseShiftB)
  2:656: ScanMag2*1 ScanPhase2 + (16*ScanPhaseShiftA + 15*ScanPhaseShiftB)
  2:657: ScanMag2*1 ScanPhase2 + (16*ScanPhaseShiftA + 16*ScanPhaseShiftB)
  2:658: ScanMag2*1 ScanPhase2 + (16*ScanPhaseShiftA + 17*ScanPhaseShiftB)
  2:659: ScanMag2*1 ScanPhase2 + (16*ScanPhaseShiftA + 18*ScanPhaseShiftB)
  2:660: ScanMag2*1 ScanPhase2 + (16*ScanPhaseShiftA + 19*ScanPhaseShiftB)
  2:661: ScanMag2*1 ScanPhase2 + (16*ScanPhaseShiftA + 20*ScanPhaseShiftB)
  2:662: ScanMag2*1 ScanPhase2 + (16*ScanPhaseShiftA + 21*ScanPhaseShiftB)
  2:663: ScanMag2*1 ScanPhase2 + (16*ScanPhaseShiftA + 22*ScanPhaseShiftB)
  2:664: ScanMag2*1 ScanPhase2 + (16*ScanPhaseShiftA + 23*ScanPhaseShiftB)
  2:665: ScanMag2*1 ScanPhase2 + (16*ScanPhaseShiftA + 24*ScanPhaseShiftB)
  2:666: ScanMag2*1 ScanPhase2 + (16*ScanPhaseShiftA + 25*ScanPhaseShiftB)
  2:667: ScanMag2*1 ScanPhase2 + (16*ScanPhaseShiftA + 26*ScanPhaseShiftB)
  2:668: ScanMag2*1 ScanPhase2 + (16*ScanPhaseShiftA + 27*ScanPhaseShiftB)
  2:669: ScanMag2*1 ScanPhase2 + (16*ScanPhaseShiftA + 28*ScanPhaseShiftB)
  2:670: ScanMag2*1 ScanPhase2 + (16*ScanPhaseShiftA + 29*ScanPhaseShiftB)
  2:671: ScanMag2*1 ScanPhase2 + (16*ScanPhaseShiftA + 30*ScanPhaseShiftB)
  2:672: ScanMag2*1 ScanPhase2 + (16*ScanPhaseShiftA + 31*ScanPhaseShiftB)
  2:673: ScanMag2*1 ScanPhase2 + (16*ScanPhaseShiftA + 32*ScanPhaseShiftB)
  2:674: ScanMag2*1 ScanPhase2 + (16*ScanPhaseShiftA + 33*ScanPhaseShiftB)
  2:675: ScanMag2*1 ScanPhase2 + (16*ScanPhaseShiftA + 34*ScanPhaseShiftB)
  2:676: ScanMag2*1 ScanPhase2 + (16*ScanPhaseShiftA + 35*ScanPhaseShiftB)
  2:677: ScanMag2*1 ScanPhase2 + (16*ScanPhaseShiftA + 36*ScanPhaseShiftB)
  2:678: ScanMag2*1 ScanPhase2 + (16*ScanPhaseShiftA + 37*ScanPhaseShiftB)
  2:679: ScanMag2*1 ScanPhase2 + (16*ScanPhaseShiftA + 38*ScanPhaseShiftB)
  2:680: ScanMag2*1 ScanPhase2 + (16*ScanPhaseShiftA + 39*ScanPhaseShiftB)
  2:681: ScanMag2*1 ScanPhase2 + (17*ScanPhaseShiftA + 0*ScanPhaseShiftB)
  2:682: ScanMag2*1 ScanPhase2 + (17*ScanPhaseShiftA + 1*ScanPhaseShiftB)
  2:683: ScanMag2*1 ScanPhase2 + (17*ScanPhaseShiftA + 2*ScanPhaseShiftB)
  2:684: ScanMag2*1 ScanPhase2 + (17*ScanPhaseShiftA + 3*ScanPhaseShiftB)
  2:685: ScanMag2*1 ScanPhase2 + (17*ScanPhaseShiftA + 4*ScanPhaseShiftB)
  2:686: ScanMag2*1 ScanPhase2 + (17*ScanPhaseShiftA + 5*ScanPhaseShiftB)
  2:687: ScanMag2*1 ScanPhase2 + (17*ScanPhaseShiftA + 6*ScanPhaseShiftB)
  2:688: ScanMag2*1 ScanPhase2 + (17*ScanPhaseShiftA + 7*ScanPhaseShiftB)
  2:689: ScanMag2*1 ScanPhase2 + (17*ScanPhaseShiftA + 8*ScanPhaseShiftB)
  2:690: ScanMag2*1 ScanPhase2 + (17*ScanPhaseShiftA + 9*ScanPhaseShiftB)
  2:691: ScanMag2*1 ScanPhase2 + (17*ScanPhaseShiftA + 10*ScanPhaseShiftB)
  2:692: ScanMag2*1 ScanPhase2 + (17*ScanPhaseShiftA + 11*ScanPhaseShiftB)
  2:693: ScanMag2*1 ScanPhase2 + (17*ScanPhaseShiftA + 12*ScanPhaseShiftB)
  2:694: ScanMag2*1 ScanPhase2 + (17*ScanPhaseShiftA + 13*ScanPhaseShiftB)
  2:695: ScanMag2*1 ScanPhase2 + (17*ScanPhaseShiftA + 14*ScanPhaseShiftB)
  2:696: ScanMag2*1 ScanPhase2 + (17*ScanPhaseShiftA + 15*ScanPhaseShiftB)
  2:697: ScanMag2*1 ScanPhase2 + (17*ScanPhaseShiftA + 16*ScanPhaseShiftB)
  2:698: ScanMag2*1 ScanPhase2 + (17*ScanPhaseShiftA + 17*ScanPhaseShiftB)
  2:699: ScanMag2*1 ScanPhase2 + (17*ScanPhaseShiftA + 18*ScanPhaseShiftB)
  2:700: ScanMag2*1 ScanPhase2 + (17*ScanPhaseShiftA + 19*ScanPhaseShiftB)
  2:701: ScanMag2*1 ScanPhase2 + (17*ScanPhaseShiftA + 20*ScanPhaseShiftB)
  2:702: ScanMag2*1 ScanPhase2 + (17*ScanPhaseShiftA + 21*ScanPhaseShiftB)
  2:703: ScanMag2*1 ScanPhase2 + (17*ScanPhaseShiftA + 22*ScanPhaseShiftB)
  2:704: ScanMag2*1 ScanPhase2 + (17*ScanPhaseShiftA + 23*ScanPhaseShiftB)
  2:705: ScanMag2*1 ScanPhase2 + (17*ScanPhaseShiftA + 24*ScanPhaseShiftB)
  2:706: ScanMag2*1 ScanPhase2 + (17*ScanPhaseShiftA + 25*ScanPhaseShiftB)
  2:707: ScanMag2*1 ScanPhase2 + (17*ScanPhaseShiftA + 26*ScanPhaseShiftB)
  2:708: ScanMag2*1 ScanPhase2 + (17*ScanPhaseShiftA + 27*ScanPhaseShiftB)
  2:709: ScanMag2*1 ScanPhase2 + (17*ScanPhaseShiftA + 28*ScanPhaseShiftB)
  2:710: ScanMag2*1 ScanPhase2 + (17*ScanPhaseShiftA + 29*ScanPhaseShiftB)
  2:711: ScanMag2*1 ScanPhase2 + (17*ScanPhaseShiftA + 30*ScanPhaseShiftB)
  2:712: ScanMag2*1 ScanPhase2 + (17*ScanPhaseShiftA + 31*ScanPhaseShiftB)
  2:713: ScanMag2*1 ScanPhase2 + (17*ScanPhaseShiftA + 32*ScanPhaseShiftB)
  2:714: ScanMag2*1 ScanPhase2 + (17*ScanPhaseShiftA + 33*ScanPhaseShiftB)
  2:715: ScanMag2*1 ScanPhase2 + (17*ScanPhaseShiftA + 34*ScanPhaseShiftB)
  2:716: ScanMag2*1 ScanPhase2 + (17*ScanPhaseShiftA + 35*ScanPhaseShiftB)
  2:717: ScanMag2*1 ScanPhase2 + (17*ScanPhaseShiftA + 36*ScanPhaseShiftB)
  2:718: ScanMag2*1 ScanPhase2 + (17*ScanPhaseShiftA + 37*ScanPhaseShiftB)
  2:719: ScanMag2*1 ScanPhase2 + (17*ScanPhaseShiftA + 38*ScanPhaseShiftB)
  2:720: ScanMag2*1 ScanPhase2 + (17*ScanPhaseShiftA + 39*ScanPhaseShiftB)
  2:721: ScanMag2*1 ScanPhase2 + (18*ScanPhaseShiftA + 0*ScanPhaseShiftB)
  2:722: ScanMag2*1 ScanPhase2 + (18*ScanPhaseShiftA + 1*ScanPhaseShiftB)
  2:723: ScanMag2*1 ScanPhase2 + (18*ScanPhaseShiftA + 2*ScanPhaseShiftB)
  2:724: ScanMag2*1 ScanPhase2 + (18*ScanPhaseShiftA + 3*ScanPhaseShiftB)
  2:725: ScanMag2*1 ScanPhase2 + (18*ScanPhaseShiftA + 4*ScanPhaseShiftB)
  2:726: ScanMag2*1 ScanPhase2 + (18*ScanPhaseShiftA + 5*ScanPhaseShiftB)
  2:727: ScanMag2*1 ScanPhase2 + (18*ScanPhaseShiftA + 6*ScanPhaseShiftB)
  2:728: ScanMag2*1 ScanPhase2 + (18*ScanPhaseShiftA + 7*ScanPhaseShiftB)
  2:729: ScanMag2*1 ScanPhase2 + (18*ScanPhaseShiftA + 8*ScanPhaseShiftB)
  2:730: ScanMag2*1 ScanPhase2 + (18*ScanPhaseShiftA + 9*ScanPhaseShiftB)
  2:731: ScanMag2*1 ScanPhase2 + (18*ScanPhaseShiftA + 10*ScanPhaseShiftB)
  2:732: ScanMag2*1 ScanPhase2 + (18*ScanPhaseShiftA + 11*ScanPhaseShiftB)
  2:733: ScanMag2*1 ScanPhase2 + (18*ScanPhaseShiftA + 12*ScanPhaseShiftB)
  2:734: ScanMag2*1 ScanPhase2 + (18*ScanPhaseShiftA + 13*ScanPhaseShiftB)
  2:735: ScanMag2*1 ScanPhase2 + (18*ScanPhaseShiftA + 14*ScanPhaseShiftB)
  2:736: ScanMag2*1 ScanPhase2 + (18*ScanPhaseShiftA + 15*ScanPhaseShiftB)
  2:737: ScanMag2*1 ScanPhase2 + (18*ScanPhaseShiftA + 16*ScanPhaseShiftB)
  2:738: ScanMag2*1 ScanPhase2 + (18*ScanPhaseShiftA + 17*ScanPhaseShiftB)
  2:739: ScanMag2*1 ScanPhase2 + (18*ScanPhaseShiftA + 18*ScanPhaseShiftB)
  2:740: ScanMag2*1 ScanPhase2 + (18*ScanPhaseShiftA + 19*ScanPhaseShiftB)
  2:741: ScanMag2*1 ScanPhase2 + (18*ScanPhaseShiftA + 20*ScanPhaseShiftB)
  2:742: ScanMag2*1 ScanPhase2 + (18*ScanPhaseShiftA + 21*ScanPhaseShiftB)
  2:743: ScanMag2*1 ScanPhase2 + (18*ScanPhaseShiftA + 22*ScanPhaseShiftB)
  2:744: ScanMag2*1 ScanPhase2 + (18*ScanPhaseShiftA + 23*ScanPhaseShiftB)
  2:745: ScanMag2*1 ScanPhase2 + (18*ScanPhaseShiftA + 24*ScanPhaseShiftB)
  2:746: ScanMag2*1 ScanPhase2 + (18*ScanPhaseShiftA + 25*ScanPhaseShiftB)
  2:747: ScanMag2*1 ScanPhase2 + (18*ScanPhaseShiftA + 26*ScanPhaseShiftB)
  2:748: ScanMag2*1 ScanPhase2 + (18*ScanPhaseShiftA + 27*ScanPhaseShiftB)
  2:749: ScanMag2*1 ScanPhase2 + (18*ScanPhaseShiftA + 28*ScanPhaseShiftB)
  2:750: ScanMag2*1 ScanPhase2 + (18*ScanPhaseShiftA + 29*ScanPhaseShiftB)
  2:751: ScanMag2*1 ScanPhase2 + (18*ScanPhaseShiftA + 30*ScanPhaseShiftB)
  2:752: ScanMag2*1 ScanPhase2 + (18*ScanPhaseShiftA + 31*ScanPhaseShiftB)
  2:753: ScanMag2*1 ScanPhase2 + (18*ScanPhaseShiftA + 32*ScanPhaseShiftB)
  2:754: ScanMag2*1 ScanPhase2 + (18*ScanPhaseShiftA + 33*ScanPhaseShiftB)
  2:755: ScanMag2*1 ScanPhase2 + (18*ScanPhaseShiftA + 34*ScanPhaseShiftB)
  2:756: ScanMag2*1 ScanPhase2 + (18*ScanPhaseShiftA + 35*ScanPhaseShiftB)
  2:757: ScanMag2*1 ScanPhase2 + (18*ScanPhaseShiftA + 36*ScanPhaseShiftB)
  2:758: ScanMag2*1 ScanPhase2 + (18*ScanPhaseShiftA + 37*ScanPhaseShiftB)
  2:759: ScanMag2*1 ScanPhase2 + (18*ScanPhaseShiftA + 38*ScanPhaseShiftB)
  2:760: ScanMag2*1 ScanPhase2 + (18*ScanPhaseShiftA + 39*ScanPhaseShiftB)
  2:761: ScanMag2*1 ScanPhase2 + (19*ScanPhaseShiftA + 0*ScanPhaseShiftB)
  2:762: ScanMag2*1 ScanPhase2 + (19*ScanPhaseShiftA + 1*ScanPhaseShiftB)
  2:763: ScanMag2*1 ScanPhase2 + (19*ScanPhaseShiftA + 2*ScanPhaseShiftB)
  2:764: ScanMag2*1 ScanPhase2 + (19*ScanPhaseShiftA + 3*ScanPhaseShiftB)
  2:765: ScanMag2*1 ScanPhase2 + (19*ScanPhaseShiftA + 4*ScanPhaseShiftB)
  2:766: ScanMag2*1 ScanPhase2 + (19*ScanPhaseShiftA + 5*ScanPhaseShiftB)
  2:767: ScanMag2*1 ScanPhase2 + (19*ScanPhaseShiftA + 6*ScanPhaseShiftB)
  2:768: ScanMag2*1 ScanPhase2 + (19*ScanPhaseShiftA + 7*ScanPhaseShiftB)
  2:769: ScanMag2*1 ScanPhase2 + (19*ScanPhaseShiftA + 8*ScanPhaseShiftB)
  2:770: ScanMag2*1 ScanPhase2 + (19*ScanPhaseShiftA + 9*ScanPhaseShiftB)
  2:771: ScanMag2*1 ScanPhase2 + (19*ScanPhaseShiftA + 10*ScanPhaseShiftB)
  2:772: ScanMag2*1 ScanPhase2 + (19*ScanPhaseShiftA + 11*ScanPhaseShiftB)
  2:773: ScanMag2*1 ScanPhase2 + (19*ScanPhaseShiftA + 12*ScanPhaseShiftB)
  2:774: ScanMag2*1 ScanPhase2 + (19*ScanPhaseShiftA + 13*ScanPhaseShiftB)
  2:775: ScanMag2*1 ScanPhase2 + (19*ScanPhaseShiftA + 14*ScanPhaseShiftB)
  2:776: ScanMag2*1 ScanPhase2 + (19*ScanPhaseShiftA + 15*ScanPhaseShiftB)
  2:777: ScanMag2*1 ScanPhase2 + (19*ScanPhaseShiftA + 16*ScanPhaseShiftB)
  2:778: ScanMag2*1 ScanPhase2 + (19*ScanPhaseShiftA + 17*ScanPhaseShiftB)
  2:779: ScanMag2*1 ScanPhase2 + (19*ScanPhaseShiftA + 18*ScanPhaseShiftB)
  2:780: ScanMag2*1 ScanPhase2 + (19*ScanPhaseShiftA + 19*ScanPhaseShiftB)
  2:781: ScanMag2*1 ScanPhase2 + (19*ScanPhaseShiftA + 20*ScanPhaseShiftB)
  2:782: ScanMag2*1 ScanPhase2 + (19*ScanPhaseShiftA + 21*ScanPhaseShiftB)
  2:783: ScanMag2*1 ScanPhase2 + (19*ScanPhaseShiftA + 22*ScanPhaseShiftB)
  2:784: ScanMag2*1 ScanPhase2 + (19*ScanPhaseShiftA + 23*ScanPhaseShiftB)
  2:785: ScanMag2*1 ScanPhase2 + (19*ScanPhaseShiftA + 24*ScanPhaseShiftB)
  2:786: ScanMag2*1 ScanPhase2 + (19*ScanPhaseShiftA + 25*ScanPhaseShiftB)
  2:787: ScanMag2*1 ScanPhase2 + (19*ScanPhaseShiftA + 26*ScanPhaseShiftB)
  2:788: ScanMag2*1 ScanPhase2 + (19*ScanPhaseShiftA + 27*ScanPhaseShiftB)
  2:789: ScanMag2*1 ScanPhase2 + (19*ScanPhaseShiftA + 28*ScanPhaseShiftB)
  2:790: ScanMag2*1 ScanPhase2 + (19*ScanPhaseShiftA + 29*ScanPhaseShiftB)
  2:791: ScanMag2*1 ScanPhase2 + (19*ScanPhaseShiftA + 30*ScanPhaseShiftB)
  2:792: ScanMag2*1 ScanPhase2 + (19*ScanPhaseShiftA + 31*ScanPhaseShiftB)
  2:793: ScanMag2*1 ScanPhase2 + (19*ScanPhaseShiftA + 32*ScanPhaseShiftB)
  2:794: ScanMag2*1 ScanPhase2 + (19*ScanPhaseShiftA + 33*ScanPhaseShiftB)
  2:795: ScanMag2*1 ScanPhase2 + (19*ScanPhaseShiftA + 34*ScanPhaseShiftB)
  2:796: ScanMag2*1 ScanPhase2 + (19*ScanPhaseShiftA + 35*ScanPhaseShiftB)
  2:797: ScanMag2*1 ScanPhase2 + (19*ScanPhaseShiftA + 36*ScanPhaseShiftB)
  2:798: ScanMag2*1 ScanPhase2 + (19*ScanPhaseShiftA + 37*ScanPhaseShiftB)
  2:799: ScanMag2*1 ScanPhase2 + (19*ScanPhaseShiftA + 38*ScanPhaseShiftB)
  2:800: ScanMag2*1 ScanPhase2 + (19*ScanPhaseShiftA + 39*ScanPhaseShiftB)
  2:801: ScanMag2*1 ScanPhase2 + (20*ScanPhaseShiftA + 0*ScanPhaseShiftB)
  2:802: ScanMag2*1 ScanPhase2 + (20*ScanPhaseShiftA + 1*ScanPhaseShiftB)
  2:803: ScanMag2*1 ScanPhase2 + (20*ScanPhaseShiftA + 2*ScanPhaseShiftB)
  2:804: ScanMag2*1 ScanPhase2 + (20*ScanPhaseShiftA + 3*ScanPhaseShiftB)
  2:805: ScanMag2*1 ScanPhase2 + (20*ScanPhaseShiftA + 4*ScanPhaseShiftB)
  2:806: ScanMag2*1 ScanPhase2 + (20*ScanPhaseShiftA + 5*ScanPhaseShiftB)
  2:807: ScanMag2*1 ScanPhase2 + (20*ScanPhaseShiftA + 6*ScanPhaseShiftB)
  2:808: ScanMag2*1 ScanPhase2 + (20*ScanPhaseShiftA + 7*ScanPhaseShiftB)
  2:809: ScanMag2*1 ScanPhase2 + (20*ScanPhaseShiftA + 8*ScanPhaseShiftB)
  2:810: ScanMag2*1 ScanPhase2 + (20*ScanPhaseShiftA + 9*ScanPhaseShiftB)
  2:811: ScanMag2*1 ScanPhase2 + (20*ScanPhaseShiftA + 10*ScanPhaseShiftB)
  2:812: ScanMag2*1 ScanPhase2 + (20*ScanPhaseShiftA + 11*ScanPhaseShiftB)
  2:813: ScanMag2*1 ScanPhase2 + (20*ScanPhaseShiftA + 12*ScanPhaseShiftB)
  2:814: ScanMag2*1 ScanPhase2 + (20*ScanPhaseShiftA + 13*ScanPhaseShiftB)
  2:815: ScanMag2*1 ScanPhase2 + (20*ScanPhaseShiftA + 14*ScanPhaseShiftB)
  2:816: ScanMag2*1 ScanPhase2 + (20*ScanPhaseShiftA + 15*ScanPhaseShiftB)
  2:817: ScanMag2*1 ScanPhase2 + (20*ScanPhaseShiftA + 16*ScanPhaseShiftB)
  2:818: ScanMag2*1 ScanPhase2 + (20*ScanPhaseShiftA + 17*ScanPhaseShiftB)
  2:819: ScanMag2*1 ScanPhase2 + (20*ScanPhaseShiftA + 18*ScanPhaseShiftB)
  2:820: ScanMag2*1 ScanPhase2 + (20*ScanPhaseShiftA + 19*ScanPhaseShiftB)
  2:821: ScanMag2*1 ScanPhase2 + (20*ScanPhaseShiftA + 20*ScanPhaseShiftB)
  2:822: ScanMag2*1 ScanPhase2 + (20*ScanPhaseShiftA + 21*ScanPhaseShiftB)
  2:823: ScanMag2*1 ScanPhase2 + (20*ScanPhaseShiftA + 22*ScanPhaseShiftB)
  2:824: ScanMag2*1 ScanPhase2 + (20*ScanPhaseShiftA + 23*ScanPhaseShiftB)
  2:825: ScanMag2*1 ScanPhase2 + (20*ScanPhaseShiftA + 24*ScanPhaseShiftB)
  2:826: ScanMag2*1 ScanPhase2 + (20*ScanPhaseShiftA + 25*ScanPhaseShiftB)
  2:827: ScanMag2*1 ScanPhase2 + (20*ScanPhaseShiftA + 26*ScanPhaseShiftB)
  2:828: ScanMag2*1 ScanPhase2 + (20*ScanPhaseShiftA + 27*ScanPhaseShiftB)
  2:829: ScanMag2*1 ScanPhase2 + (20*ScanPhaseShiftA + 28*ScanPhaseShiftB)
  2:830: ScanMag2*1 ScanPhase2 + (20*ScanPhaseShiftA + 29*ScanPhaseShiftB)
  2:831: ScanMag2*1 ScanPhase2 + (20*ScanPhaseShiftA + 30*ScanPhaseShiftB)
  2:832: ScanMag2*1 ScanPhase2 + (20*ScanPhaseShiftA + 31*ScanPhaseShiftB)
  2:833: ScanMag2*1 ScanPhase2 + (20*ScanPhaseShiftA + 32*ScanPhaseShiftB)
  2:834: ScanMag2*1 ScanPhase2 + (20*ScanPhaseShiftA + 33*ScanPhaseShiftB)
  2:835: ScanMag2*1 ScanPhase2 + (20*ScanPhaseShiftA + 34*ScanPhaseShiftB)
  2:836: ScanMag2*1 ScanPhase2 + (20*ScanPhaseShiftA + 35*ScanPhaseShiftB)
  2:837: ScanMag2*1 ScanPhase2 + (20*ScanPhaseShiftA + 36*ScanPhaseShiftB)
  2:838: ScanMag2*1 ScanPhase2 + (20*ScanPhaseShiftA + 37*ScanPhaseShiftB)
  2:839: ScanMag2*1 ScanPhase2 + (20*ScanPhaseShiftA + 38*ScanPhaseShiftB)
  2:840: ScanMag2*1 ScanPhase2 + (20*ScanPhaseShiftA + 39*ScanPhaseShiftB)
  2:841: ScanMag2*1 ScanPhase2 + (21*ScanPhaseShiftA + 0*ScanPhaseShiftB)
  2:842: ScanMag2*1 ScanPhase2 + (21*ScanPhaseShiftA + 1*ScanPhaseShiftB)
  2:843: ScanMag2*1 ScanPhase2 + (21*ScanPhaseShiftA + 2*ScanPhaseShiftB)
  2:844: ScanMag2*1 ScanPhase2 + (21*ScanPhaseShiftA + 3*ScanPhaseShiftB)
  2:845: ScanMag2*1 ScanPhase2 + (21*ScanPhaseShiftA + 4*ScanPhaseShiftB)
  2:846: ScanMag2*1 ScanPhase2 + (21*ScanPhaseShiftA + 5*ScanPhaseShiftB)
  2:847: ScanMag2*1 ScanPhase2 + (21*ScanPhaseShiftA + 6*ScanPhaseShiftB)
  2:848: ScanMag2*1 ScanPhase2 + (21*ScanPhaseShiftA + 7*ScanPhaseShiftB)
  2:849: ScanMag2*1 ScanPhase2 + (21*ScanPhaseShiftA + 8*ScanPhaseShiftB)
  2:850: ScanMag2*1 ScanPhase2 + (21*ScanPhaseShiftA + 9*ScanPhaseShiftB)
  2:851: ScanMag2*1 ScanPhase2 + (21*ScanPhaseShiftA + 10*ScanPhaseShiftB)
  2:852: ScanMag2*1 ScanPhase2 + (21*ScanPhaseShiftA + 11*ScanPhaseShiftB)
  2:853: ScanMag2*1 ScanPhase2 + (21*ScanPhaseShiftA + 12*ScanPhaseShiftB)
  2:854: ScanMag2*1 ScanPhase2 + (21*ScanPhaseShiftA + 13*ScanPhaseShiftB)
  2:855: ScanMag2*1 ScanPhase2 + (21*ScanPhaseShiftA + 14*ScanPhaseShiftB)
  2:856: ScanMag2*1 ScanPhase2 + (21*ScanPhaseShiftA + 15*ScanPhaseShiftB)
  2:857: ScanMag2*1 ScanPhase2 + (21*ScanPhaseShiftA + 16*ScanPhaseShiftB)
  2:858: ScanMag2*1 ScanPhase2 + (21*ScanPhaseShiftA + 17*ScanPhaseShiftB)
  2:859: ScanMag2*1 ScanPhase2 + (21*ScanPhaseShiftA + 18*ScanPhaseShiftB)
  2:860: ScanMag2*1 ScanPhase2 + (21*ScanPhaseShiftA + 19*ScanPhaseShiftB)
  2:861: ScanMag2*1 ScanPhase2 + (21*ScanPhaseShiftA + 20*ScanPhaseShiftB)
  2:862: ScanMag2*1 ScanPhase2 + (21*ScanPhaseShiftA + 21*ScanPhaseShiftB)
  2:863: ScanMag2*1 ScanPhase2 + (21*ScanPhaseShiftA + 22*ScanPhaseShiftB)
  2:864: ScanMag2*1 ScanPhase2 + (21*ScanPhaseShiftA + 23*ScanPhaseShiftB)
  2:865: ScanMag2*1 ScanPhase2 + (21*ScanPhaseShiftA + 24*ScanPhaseShiftB)
  2:866: ScanMag2*1 ScanPhase2 + (21*ScanPhaseShiftA + 25*ScanPhaseShiftB)
  2:867: ScanMag2*1 ScanPhase2 + (21*ScanPhaseShiftA + 26*ScanPhaseShiftB)
  2:868: ScanMag2*1 ScanPhase2 + (21*ScanPhaseShiftA + 27*ScanPhaseShiftB)
  2:869: ScanMag2*1 ScanPhase2 + (21*ScanPhaseShiftA + 28*ScanPhaseShiftB)
  2:870: ScanMag2*1 ScanPhase2 + (21*ScanPhaseShiftA + 29*ScanPhaseShiftB)
  2:871: ScanMag2*1 ScanPhase2 + (21*ScanPhaseShiftA + 30*ScanPhaseShiftB)
  2:872: ScanMag2*1 ScanPhase2 + (21*ScanPhaseShiftA + 31*ScanPhaseShiftB)
  2:873: ScanMag2*1 ScanPhase2 + (21*ScanPhaseShiftA + 32*ScanPhaseShiftB)
  2:874: ScanMag2*1 ScanPhase2 + (21*ScanPhaseShiftA + 33*ScanPhaseShiftB)
  2:875: ScanMag2*1 ScanPhase2 + (21*ScanPhaseShiftA + 34*ScanPhaseShiftB)
  2:876: ScanMag2*1 ScanPhase2 + (21*ScanPhaseShiftA + 35*ScanPhaseShiftB)
  2:877: ScanMag2*1 ScanPhase2 + (21*ScanPhaseShiftA + 36*ScanPhaseShiftB)
  2:878: ScanMag2*1 ScanPhase2 + (21*ScanPhaseShiftA + 37*ScanPhaseShiftB)
  2:879: ScanMag2*1 ScanPhase2 + (21*ScanPhaseShiftA + 38*ScanPhaseShiftB)
  2:880: ScanMag2*1 ScanPhase2 + (21*ScanPhaseShiftA + 39*ScanPhaseShiftB)
  2:881: ScanMag2*1 ScanPhase2 + (22*ScanPhaseShiftA + 0*ScanPhaseShiftB)
  2:882: ScanMag2*1 ScanPhase2 + (22*ScanPhaseShiftA + 1*ScanPhaseShiftB)
  2:883: ScanMag2*1 ScanPhase2 + (22*ScanPhaseShiftA + 2*ScanPhaseShiftB)
  2:884: ScanMag2*1 ScanPhase2 + (22*ScanPhaseShiftA + 3*ScanPhaseShiftB)
  2:885: ScanMag2*1 ScanPhase2 + (22*ScanPhaseShiftA + 4*ScanPhaseShiftB)
  2:886: ScanMag2*1 ScanPhase2 + (22*ScanPhaseShiftA + 5*ScanPhaseShiftB)
  2:887: ScanMag2*1 ScanPhase2 + (22*ScanPhaseShiftA + 6*ScanPhaseShiftB)
  2:888: ScanMag2*1 ScanPhase2 + (22*ScanPhaseShiftA + 7*ScanPhaseShiftB)
  2:889: ScanMag2*1 ScanPhase2 + (22*ScanPhaseShiftA + 8*ScanPhaseShiftB)
  2:890: ScanMag2*1 ScanPhase2 + (22*ScanPhaseShiftA + 9*ScanPhaseShiftB)
  2:891: ScanMag2*1 ScanPhase2 + (22*ScanPhaseShiftA + 10*ScanPhaseShiftB)
  2:892: ScanMag2*1 ScanPhase2 + (22*ScanPhaseShiftA + 11*ScanPhaseShiftB)
  2:893: ScanMag2*1 ScanPhase2 + (22*ScanPhaseShiftA + 12*ScanPhaseShiftB)
  2:894: ScanMag2*1 ScanPhase2 + (22*ScanPhaseShiftA + 13*ScanPhaseShiftB)
  2:895: ScanMag2*1 ScanPhase2 + (22*ScanPhaseShiftA + 14*ScanPhaseShiftB)
  2:896: ScanMag2*1 ScanPhase2 + (22*ScanPhaseShiftA + 15*ScanPhaseShiftB)
  2:897: ScanMag2*1 ScanPhase2 + (22*ScanPhaseShiftA + 16*ScanPhaseShiftB)
  2:898: ScanMag2*1 ScanPhase2 + (22*ScanPhaseShiftA + 17*ScanPhaseShiftB)
  2:899: ScanMag2*1 ScanPhase2 + (22*ScanPhaseShiftA + 18*ScanPhaseShiftB)
  2:900: ScanMag2*1 ScanPhase2 + (22*ScanPhaseShiftA + 19*ScanPhaseShiftB)
  2:901: ScanMag2*1 ScanPhase2 + (22*ScanPhaseShiftA + 20*ScanPhaseShiftB)
  2:902: ScanMag2*1 ScanPhase2 + (22*ScanPhaseShiftA + 21*ScanPhaseShiftB)
  2:903: ScanMag2*1 ScanPhase2 + (22*ScanPhaseShiftA + 22*ScanPhaseShiftB)
  2:904: ScanMag2*1 ScanPhase2 + (22*ScanPhaseShiftA + 23*ScanPhaseShiftB)
  2:905: ScanMag2*1 ScanPhase2 + (22*ScanPhaseShiftA + 24*ScanPhaseShiftB)
  2:906: ScanMag2*1 ScanPhase2 + (22*ScanPhaseShiftA + 25*ScanPhaseShiftB)
  2:907: ScanMag2*1 ScanPhase2 + (22*ScanPhaseShiftA + 26*ScanPhaseShiftB)
  2:908: ScanMag2*1 ScanPhase2 + (22*ScanPhaseShiftA + 27*ScanPhaseShiftB)
  2:909: ScanMag2*1 ScanPhase2 + (22*ScanPhaseShiftA + 28*ScanPhaseShiftB)
  2:910: ScanMag2*1 ScanPhase2 + (22*ScanPhaseShiftA + 29*ScanPhaseShiftB)
  2:911: ScanMag2*1 ScanPhase2 + (22*ScanPhaseShiftA + 30*ScanPhaseShiftB)
  2:912: ScanMag2*1 ScanPhase2 + (22*ScanPhaseShiftA + 31*ScanPhaseShiftB)
  2:913: ScanMag2*1 ScanPhase2 + (22*ScanPhaseShiftA + 32*ScanPhaseShiftB)
  2:914: ScanMag2*1 ScanPhase2 + (22*ScanPhaseShiftA + 33*ScanPhaseShiftB)
  2:915: ScanMag2*1 ScanPhase2 + (22*ScanPhaseShiftA + 34*ScanPhaseShiftB)
  2:916: ScanMag2*1 ScanPhase2 + (22*ScanPhaseShiftA + 35*ScanPhaseShiftB)
  2:917: ScanMag2*1 ScanPhase2 + (22*ScanPhaseShiftA + 36*ScanPhaseShiftB)
  2:918: ScanMag2*1 ScanPhase2 + (22*ScanPhaseShiftA + 37*ScanPhaseShiftB)
  2:919: ScanMag2*1 ScanPhase2 + (22*ScanPhaseShiftA + 38*ScanPhaseShiftB)
  2:920: ScanMag2*1 ScanPhase2 + (22*ScanPhaseShiftA + 39*ScanPhaseShiftB)
  2:921: ScanMag2*1 ScanPhase2 + (23*ScanPhaseShiftA + 0*ScanPhaseShiftB)
  2:922: ScanMag2*1 ScanPhase2 + (23*ScanPhaseShiftA + 1*ScanPhaseShiftB)
  2:923: ScanMag2*1 ScanPhase2 + (23*ScanPhaseShiftA + 2*ScanPhaseShiftB)
  2:924: ScanMag2*1 ScanPhase2 + (23*ScanPhaseShiftA + 3*ScanPhaseShiftB)
  2:925: ScanMag2*1 ScanPhase2 + (23*ScanPhaseShiftA + 4*ScanPhaseShiftB)
  2:926: ScanMag2*1 ScanPhase2 + (23*ScanPhaseShiftA + 5*ScanPhaseShiftB)
  2:927: ScanMag2*1 ScanPhase2 + (23*ScanPhaseShiftA + 6*ScanPhaseShiftB)
  2:928: ScanMag2*1 ScanPhase2 + (23*ScanPhaseShiftA + 7*ScanPhaseShiftB)
  2:929: ScanMag2*1 ScanPhase2 + (23*ScanPhaseShiftA + 8*ScanPhaseShiftB)
  2:930: ScanMag2*1 ScanPhase2 + (23*ScanPhaseShiftA + 9*ScanPhaseShiftB)
  2:931: ScanMag2*1 ScanPhase2 + (23*ScanPhaseShiftA + 10*ScanPhaseShiftB)
  2:932: ScanMag2*1 ScanPhase2 + (23*ScanPhaseShiftA + 11*ScanPhaseShiftB)
  2:933: ScanMag2*1 ScanPhase2 + (23*ScanPhaseShiftA + 12*ScanPhaseShiftB)
  2:934: ScanMag2*1 ScanPhase2 + (23*ScanPhaseShiftA + 13*ScanPhaseShiftB)
  2:935: ScanMag2*1 ScanPhase2 + (23*ScanPhaseShiftA + 14*ScanPhaseShiftB)
  2:936: ScanMag2*1 ScanPhase2 + (23*ScanPhaseShiftA + 15*ScanPhaseShiftB)
  2:937: ScanMag2*1 ScanPhase2 + (23*ScanPhaseShiftA + 16*ScanPhaseShiftB)
  2:938: ScanMag2*1 ScanPhase2 + (23*ScanPhaseShiftA + 17*ScanPhaseShiftB)
  2:939: ScanMag2*1 ScanPhase2 + (23*ScanPhaseShiftA + 18*ScanPhaseShiftB)
  2:940: ScanMag2*1 ScanPhase2 + (23*ScanPhaseShiftA + 19*ScanPhaseShiftB)
  2:941: ScanMag2*1 ScanPhase2 + (23*ScanPhaseShiftA + 20*ScanPhaseShiftB)
  2:942: ScanMag2*1 ScanPhase2 + (23*ScanPhaseShiftA + 21*ScanPhaseShiftB)
  2:943: ScanMag2*1 ScanPhase2 + (23*ScanPhaseShiftA + 22*ScanPhaseShiftB)
  2:944: ScanMag2*1 ScanPhase2 + (23*ScanPhaseShiftA + 23*ScanPhaseShiftB)
  2:945: ScanMag2*1 ScanPhase2 + (23*ScanPhaseShiftA + 24*ScanPhaseShiftB)
  2:946: ScanMag2*1 ScanPhase2 + (23*ScanPhaseShiftA + 25*ScanPhaseShiftB)
  2:947: ScanMag2*1 ScanPhase2 + (23*ScanPhaseShiftA + 26*ScanPhaseShiftB)
  2:948: ScanMag2*1 ScanPhase2 + (23*ScanPhaseShiftA + 27*ScanPhaseShiftB)
  2:949: ScanMag2*1 ScanPhase2 + (23*ScanPhaseShiftA + 28*ScanPhaseShiftB)
  2:950: ScanMag2*1 ScanPhase2 + (23*ScanPhaseShiftA + 29*ScanPhaseShiftB)
  2:951: ScanMag2*1 ScanPhase2 + (23*ScanPhaseShiftA + 30*ScanPhaseShiftB)
  2:952: ScanMag2*1 ScanPhase2 + (23*ScanPhaseShiftA + 31*ScanPhaseShiftB)
  2:953: ScanMag2*1 ScanPhase2 + (23*ScanPhaseShiftA + 32*ScanPhaseShiftB)
  2:954: ScanMag2*1 ScanPhase2 + (23*ScanPhaseShiftA + 33*ScanPhaseShiftB)
  2:955: ScanMag2*1 ScanPhase2 + (23*ScanPhaseShiftA + 34*ScanPhaseShiftB)
  2:956: ScanMag2*1 ScanPhase2 + (23*ScanPhaseShiftA + 35*ScanPhaseShiftB)
  2:957: ScanMag2*1 ScanPhase2 + (23*ScanPhaseShiftA + 36*ScanPhaseShiftB)
  2:958: ScanMag2*1 ScanPhase2 + (23*ScanPhaseShiftA + 37*ScanPhaseShiftB)
  2:959: ScanMag2*1 ScanPhase2 + (23*ScanPhaseShiftA + 38*ScanPhaseShiftB)
  2:960: ScanMag2*1 ScanPhase2 + (23*ScanPhaseShiftA + 39*ScanPhaseShiftB)
  2:961: ScanMag2*1 ScanPhase2 + (24*ScanPhaseShiftA + 0*ScanPhaseShiftB)
  2:962: ScanMag2*1 ScanPhase2 + (24*ScanPhaseShiftA + 1*ScanPhaseShiftB)
  2:963: ScanMag2*1 ScanPhase2 + (24*ScanPhaseShiftA + 2*ScanPhaseShiftB)
  2:964: ScanMag2*1 ScanPhase2 + (24*ScanPhaseShiftA + 3*ScanPhaseShiftB)
  2:965: ScanMag2*1 ScanPhase2 + (24*ScanPhaseShiftA + 4*ScanPhaseShiftB)
  2:966: ScanMag2*1 ScanPhase2 + (24*ScanPhaseShiftA + 5*ScanPhaseShiftB)
  2:967: ScanMag2*1 ScanPhase2 + (24*ScanPhaseShiftA + 6*ScanPhaseShiftB)
  2:968: ScanMag2*1 ScanPhase2 + (24*ScanPhaseShiftA + 7*ScanPhaseShiftB)
  2:969: ScanMag2*1 ScanPhase2 + (24*ScanPhaseShiftA + 8*ScanPhaseShiftB)
  2:970: ScanMag2*1 ScanPhase2 + (24*ScanPhaseShiftA + 9*ScanPhaseShiftB)
  2:971: ScanMag2*1 ScanPhase2 + (24*ScanPhaseShiftA + 10*ScanPhaseShiftB)
  2:972: ScanMag2*1 ScanPhase2 + (24*ScanPhaseShiftA + 11*ScanPhaseShiftB)
  2:973: ScanMag2*1 ScanPhase2 + (24*ScanPhaseShiftA + 12*ScanPhaseShiftB)
  2:974: ScanMag2*1 ScanPhase2 + (24*ScanPhaseShiftA + 13*ScanPhaseShiftB)
  2:975: ScanMag2*1 ScanPhase2 + (24*ScanPhaseShiftA + 14*ScanPhaseShiftB)
  2:976: ScanMag2*1 ScanPhase2 + (24*ScanPhaseShiftA + 15*ScanPhaseShiftB)
  2:977: ScanMag2*1 ScanPhase2 + (24*ScanPhaseShiftA + 16*ScanPhaseShiftB)
  2:978: ScanMag2*1 ScanPhase2 + (24*ScanPhaseShiftA + 17*ScanPhaseShiftB)
  2:979: ScanMag2*1 ScanPhase2 + (24*ScanPhaseShiftA + 18*ScanPhaseShiftB)
  2:980: ScanMag2*1 ScanPhase2 + (24*ScanPhaseShiftA + 19*ScanPhaseShiftB)
  2:981: ScanMag2*1 ScanPhase2 + (24*ScanPhaseShiftA + 20*ScanPhaseShiftB)
  2:982: ScanMag2*1 ScanPhase2 + (24*ScanPhaseShiftA + 21*ScanPhaseShiftB)
  2:983: ScanMag2*1 ScanPhase2 + (24*ScanPhaseShiftA + 22*ScanPhaseShiftB)
  2:984: ScanMag2*1 ScanPhase2 + (24*ScanPhaseShiftA + 23*ScanPhaseShiftB)
  2:985: ScanMag2*1 ScanPhase2 + (24*ScanPhaseShiftA + 24*ScanPhaseShiftB)
  2:986: ScanMag2*1 ScanPhase2 + (24*ScanPhaseShiftA + 25*ScanPhaseShiftB)
  2:987: ScanMag2*1 ScanPhase2 + (24*ScanPhaseShiftA + 26*ScanPhaseShiftB)
  2:988: ScanMag2*1 ScanPhase2 + (24*ScanPhaseShiftA + 27*ScanPhaseShiftB)
  2:989: ScanMag2*1 ScanPhase2 + (24*ScanPhaseShiftA + 28*ScanPhaseShiftB)
  2:990: ScanMag2*1 ScanPhase2 + (24*ScanPhaseShiftA + 29*ScanPhaseShiftB)
  2:991: ScanMag2*1 ScanPhase2 + (24*ScanPhaseShiftA + 30*ScanPhaseShiftB)
  2:992: ScanMag2*1 ScanPhase2 + (24*ScanPhaseShiftA + 31*ScanPhaseShiftB)
  2:993: ScanMag2*1 ScanPhase2 + (24*ScanPhaseShiftA + 32*ScanPhaseShiftB)
  2:994: ScanMag2*1 ScanPhase2 + (24*ScanPhaseShiftA + 33*ScanPhaseShiftB)
  2:995: ScanMag2*1 ScanPhase2 + (24*ScanPhaseShiftA + 34*ScanPhaseShiftB)
  2:996: ScanMag2*1 ScanPhase2 + (24*ScanPhaseShiftA + 35*ScanPhaseShiftB)
  2:997: ScanMag2*1 ScanPhase2 + (24*ScanPhaseShiftA + 36*ScanPhaseShiftB)
  2:998: ScanMag2*1 ScanPhase2 + (24*ScanPhaseShiftA + 37*ScanPhaseShiftB)
  2:999: ScanMag2*1 ScanPhase2 + (24*ScanPhaseShiftA + 38*ScanPhaseShiftB)
  2:1000: ScanMag2*1 ScanPhase2 + (24*ScanPhaseShiftA + 39*ScanPhaseShiftB)
  2:1001: ScanMag2*1 ScanPhase2 + (25*ScanPhaseShiftA + 0*ScanPhaseShiftB)
  2:1002: ScanMag2*1 ScanPhase2 + (25*ScanPhaseShiftA + 1*ScanPhaseShiftB)
  2:1003: ScanMag2*1 ScanPhase2 + (25*ScanPhaseShiftA + 2*ScanPhaseShiftB)
  2:1004: ScanMag2*1 ScanPhase2 + (25*ScanPhaseShiftA + 3*ScanPhaseShiftB)
  2:1005: ScanMag2*1 ScanPhase2 + (25*ScanPhaseShiftA + 4*ScanPhaseShiftB)
  2:1006: ScanMag2*1 ScanPhase2 + (25*ScanPhaseShiftA + 5*ScanPhaseShiftB)
  2:1007: ScanMag2*1 ScanPhase2 + (25*ScanPhaseShiftA + 6*ScanPhaseShiftB)
  2:1008: ScanMag2*1 ScanPhase2 + (25*ScanPhaseShiftA + 7*ScanPhaseShiftB)
  2:1009: ScanMag2*1 ScanPhase2 + (25*ScanPhaseShiftA + 8*ScanPhaseShiftB)
  2:1010: ScanMag2*1 ScanPhase2 + (25*ScanPhaseShiftA + 9*ScanPhaseShiftB)
  2:1011: ScanMag2*1 ScanPhase2 + (25*ScanPhaseShiftA + 10*ScanPhaseShiftB)
  2:1012: ScanMag2*1 ScanPhase2 + (25*ScanPhaseShiftA + 11*ScanPhaseShiftB)
  2:1013: ScanMag2*1 ScanPhase2 + (25*ScanPhaseShiftA + 12*ScanPhaseShiftB)
  2:1014: ScanMag2*1 ScanPhase2 + (25*ScanPhaseShiftA + 13*ScanPhaseShiftB)
  2:1015: ScanMag2*1 ScanPhase2 + (25*ScanPhaseShiftA + 14*ScanPhaseShiftB)
  2:1016: ScanMag2*1 ScanPhase2 + (25*ScanPhaseShiftA + 15*ScanPhaseShiftB)
  2:1017: ScanMag2*1 ScanPhase2 + (25*ScanPhaseShiftA + 16*ScanPhaseShiftB)
  2:1018: ScanMag2*1 ScanPhase2 + (25*ScanPhaseShiftA + 17*ScanPhaseShiftB)
  2:1019: ScanMag2*1 ScanPhase2 + (25*ScanPhaseShiftA + 18*ScanPhaseShiftB)
  2:1020: ScanMag2*1 ScanPhase2 + (25*ScanPhaseShiftA + 19*ScanPhaseShiftB)
  2:1021: ScanMag2*1 ScanPhase2 + (25*ScanPhaseShiftA + 20*ScanPhaseShiftB)
  2:1022: ScanMag2*1 ScanPhase2 + (25*ScanPhaseShiftA + 21*ScanPhaseShiftB)
  2:1023: ScanMag2*1 ScanPhase2 + (25*ScanPhaseShiftA + 22*ScanPhaseShiftB)
  2:1024: ScanMag2*1 ScanPhase2 + (25*ScanPhaseShiftA + 23*ScanPhaseShiftB)
  2:1025: ScanMag2*1 ScanPhase2 + (25*ScanPhaseShiftA + 24*ScanPhaseShiftB)
  2:1026: ScanMag2*1 ScanPhase2 + (25*ScanPhaseShiftA + 25*ScanPhaseShiftB)
  2:1027: ScanMag2*1 ScanPhase2 + (25*ScanPhaseShiftA + 26*ScanPhaseShiftB)
  2:1028: ScanMag2*1 ScanPhase2 + (25*ScanPhaseShiftA + 27*ScanPhaseShiftB)
  2:1029: ScanMag2*1 ScanPhase2 + (25*ScanPhaseShiftA + 28*ScanPhaseShiftB)
  2:1030: ScanMag2*1 ScanPhase2 + (25*ScanPhaseShiftA + 29*ScanPhaseShiftB)
  2:1031: ScanMag2*1 ScanPhase2 + (25*ScanPhaseShiftA + 30*ScanPhaseShiftB)
  2:1032: ScanMag2*1 ScanPhase2 + (25*ScanPhaseShiftA + 31*ScanPhaseShiftB)
  2:1033: ScanMag2*1 ScanPhase2 + (25*ScanPhaseShiftA + 32*ScanPhaseShiftB)
  2:1034: ScanMag2*1 ScanPhase2 + (25*ScanPhaseShiftA + 33*ScanPhaseShiftB)
  2:1035: ScanMag2*1 ScanPhase2 + (25*ScanPhaseShiftA + 34*ScanPhaseShiftB)
  2:1036: ScanMag2*1 ScanPhase2 + (25*ScanPhaseShiftA + 35*ScanPhaseShiftB)
  2:1037: ScanMag2*1 ScanPhase2 + (25*ScanPhaseShiftA + 36*ScanPhaseShiftB)
  2:1038: ScanMag2*1 ScanPhase2 + (25*ScanPhaseShiftA + 37*ScanPhaseShiftB)
  2:1039: ScanMag2*1 ScanPhase2 + (25*ScanPhaseShiftA + 38*ScanPhaseShiftB)
  2:1040: ScanMag2*1 ScanPhase2 + (25*ScanPhaseShiftA + 39*ScanPhaseShiftB)
  2:1041: ScanMag2*1 ScanPhase2 + (26*ScanPhaseShiftA + 0*ScanPhaseShiftB)
  2:1042: ScanMag2*1 ScanPhase2 + (26*ScanPhaseShiftA + 1*ScanPhaseShiftB)
  2:1043: ScanMag2*1 ScanPhase2 + (26*ScanPhaseShiftA + 2*ScanPhaseShiftB)
  2:1044: ScanMag2*1 ScanPhase2 + (26*ScanPhaseShiftA + 3*ScanPhaseShiftB)
  2:1045: ScanMag2*1 ScanPhase2 + (26*ScanPhaseShiftA + 4*ScanPhaseShiftB)
  2:1046: ScanMag2*1 ScanPhase2 + (26*ScanPhaseShiftA + 5*ScanPhaseShiftB)
  2:1047: ScanMag2*1 ScanPhase2 + (26*ScanPhaseShiftA + 6*ScanPhaseShiftB)
  2:1048: ScanMag2*1 ScanPhase2 + (26*ScanPhaseShiftA + 7*ScanPhaseShiftB)
  2:1049: ScanMag2*1 ScanPhase2 + (26*ScanPhaseShiftA + 8*ScanPhaseShiftB)
  2:1050: ScanMag2*1 ScanPhase2 + (26*ScanPhaseShiftA + 9*ScanPhaseShiftB)
  2:1051: ScanMag2*1 ScanPhase2 + (26*ScanPhaseShiftA + 10*ScanPhaseShiftB)
  2:1052: ScanMag2*1 ScanPhase2 + (26*ScanPhaseShiftA + 11*ScanPhaseShiftB)
  2:1053: ScanMag2*1 ScanPhase2 + (26*ScanPhaseShiftA + 12*ScanPhaseShiftB)
  2:1054: ScanMag2*1 ScanPhase2 + (26*ScanPhaseShiftA + 13*ScanPhaseShiftB)
  2:1055: ScanMag2*1 ScanPhase2 + (26*ScanPhaseShiftA + 14*ScanPhaseShiftB)
  2:1056: ScanMag2*1 ScanPhase2 + (26*ScanPhaseShiftA + 15*ScanPhaseShiftB)
  2:1057: ScanMag2*1 ScanPhase2 + (26*ScanPhaseShiftA + 16*ScanPhaseShiftB)
  2:1058: ScanMag2*1 ScanPhase2 + (26*ScanPhaseShiftA + 17*ScanPhaseShiftB)
  2:1059: ScanMag2*1 ScanPhase2 + (26*ScanPhaseShiftA + 18*ScanPhaseShiftB)
  2:1060: ScanMag2*1 ScanPhase2 + (26*ScanPhaseShiftA + 19*ScanPhaseShiftB)
  2:1061: ScanMag2*1 ScanPhase2 + (26*ScanPhaseShiftA + 20*ScanPhaseShiftB)
  2:1062: ScanMag2*1 ScanPhase2 + (26*ScanPhaseShiftA + 21*ScanPhaseShiftB)
  2:1063: ScanMag2*1 ScanPhase2 + (26*ScanPhaseShiftA + 22*ScanPhaseShiftB)
  2:1064: ScanMag2*1 ScanPhase2 + (26*ScanPhaseShiftA + 23*ScanPhaseShiftB)
  2:1065: ScanMag2*1 ScanPhase2 + (26*ScanPhaseShiftA + 24*ScanPhaseShiftB)
  2:1066: ScanMag2*1 ScanPhase2 + (26*ScanPhaseShiftA + 25*ScanPhaseShiftB)
  2:1067: ScanMag2*1 ScanPhase2 + (26*ScanPhaseShiftA + 26*ScanPhaseShiftB)
  2:1068: ScanMag2*1 ScanPhase2 + (26*ScanPhaseShiftA + 27*ScanPhaseShiftB)
  2:1069: ScanMag2*1 ScanPhase2 + (26*ScanPhaseShiftA + 28*ScanPhaseShiftB)
  2:1070: ScanMag2*1 ScanPhase2 + (26*ScanPhaseShiftA + 29*ScanPhaseShiftB)
  2:1071: ScanMag2*1 ScanPhase2 + (26*ScanPhaseShiftA + 30*ScanPhaseShiftB)
  2:1072: ScanMag2*1 ScanPhase2 + (26*ScanPhaseShiftA + 31*ScanPhaseShiftB)
  2:1073: ScanMag2*1 ScanPhase2 + (26*ScanPhaseShiftA + 32*ScanPhaseShiftB)
  2:1074: ScanMag2*1 ScanPhase2 + (26*ScanPhaseShiftA + 33*ScanPhaseShiftB)
  2:1075: ScanMag2*1 ScanPhase2 + (26*ScanPhaseShiftA + 34*ScanPhaseShiftB)
  2:1076: ScanMag2*1 ScanPhase2 + (26*ScanPhaseShiftA + 35*ScanPhaseShiftB)
  2:1077: ScanMag2*1 ScanPhase2 + (26*ScanPhaseShiftA + 36*ScanPhaseShiftB)
  2:1078: ScanMag2*1 ScanPhase2 + (26*ScanPhaseShiftA + 37*ScanPhaseShiftB)
  2:1079: ScanMag2*1 ScanPhase2 + (26*ScanPhaseShiftA + 38*ScanPhaseShiftB)
  2:1080: ScanMag2*1 ScanPhase2 + (26*ScanPhaseShiftA + 39*ScanPhaseShiftB)
  2:1081: ScanMag2*1 ScanPhase2 + (27*ScanPhaseShiftA + 0*ScanPhaseShiftB)
  2:1082: ScanMag2*1 ScanPhase2 + (27*ScanPhaseShiftA + 1*ScanPhaseShiftB)
  2:1083: ScanMag2*1 ScanPhase2 + (27*ScanPhaseShiftA + 2*ScanPhaseShiftB)
  2:1084: ScanMag2*1 ScanPhase2 + (27*ScanPhaseShiftA + 3*ScanPhaseShiftB)
  2:1085: ScanMag2*1 ScanPhase2 + (27*ScanPhaseShiftA + 4*ScanPhaseShiftB)
  2:1086: ScanMag2*1 ScanPhase2 + (27*ScanPhaseShiftA + 5*ScanPhaseShiftB)
  2:1087: ScanMag2*1 ScanPhase2 + (27*ScanPhaseShiftA + 6*ScanPhaseShiftB)
  2:1088: ScanMag2*1 ScanPhase2 + (27*ScanPhaseShiftA + 7*ScanPhaseShiftB)
  2:1089: ScanMag2*1 ScanPhase2 + (27*ScanPhaseShiftA + 8*ScanPhaseShiftB)
  2:1090: ScanMag2*1 ScanPhase2 + (27*ScanPhaseShiftA + 9*ScanPhaseShiftB)
  2:1091: ScanMag2*1 ScanPhase2 + (27*ScanPhaseShiftA + 10*ScanPhaseShiftB)
  2:1092: ScanMag2*1 ScanPhase2 + (27*ScanPhaseShiftA + 11*ScanPhaseShiftB)
  2:1093: ScanMag2*1 ScanPhase2 + (27*ScanPhaseShiftA + 12*ScanPhaseShiftB)
  2:1094: ScanMag2*1 ScanPhase2 + (27*ScanPhaseShiftA + 13*ScanPhaseShiftB)
  2:1095: ScanMag2*1 ScanPhase2 + (27*ScanPhaseShiftA + 14*ScanPhaseShiftB)
  2:1096: ScanMag2*1 ScanPhase2 + (27*ScanPhaseShiftA + 15*ScanPhaseShiftB)
  2:1097: ScanMag2*1 ScanPhase2 + (27*ScanPhaseShiftA + 16*ScanPhaseShiftB)
  2:1098: ScanMag2*1 ScanPhase2 + (27*ScanPhaseShiftA + 17*ScanPhaseShiftB)
  2:1099: ScanMag2*1 ScanPhase2 + (27*ScanPhaseShiftA + 18*ScanPhaseShiftB)
  2:1100: ScanMag2*1 ScanPhase2 + (27*ScanPhaseShiftA + 19*ScanPhaseShiftB)
  2:1101: ScanMag2*1 ScanPhase2 + (27*ScanPhaseShiftA + 20*ScanPhaseShiftB)
  2:1102: ScanMag2*1 ScanPhase2 + (27*ScanPhaseShiftA + 21*ScanPhaseShiftB)
  2:1103: ScanMag2*1 ScanPhase2 + (27*ScanPhaseShiftA + 22*ScanPhaseShiftB)
  2:1104: ScanMag2*1 ScanPhase2 + (27*ScanPhaseShiftA + 23*ScanPhaseShiftB)
  2:1105: ScanMag2*1 ScanPhase2 + (27*ScanPhaseShiftA + 24*ScanPhaseShiftB)
  2:1106: ScanMag2*1 ScanPhase2 + (27*ScanPhaseShiftA + 25*ScanPhaseShiftB)
  2:1107: ScanMag2*1 ScanPhase2 + (27*ScanPhaseShiftA + 26*ScanPhaseShiftB)
  2:1108: ScanMag2*1 ScanPhase2 + (27*ScanPhaseShiftA + 27*ScanPhaseShiftB)
  2:1109: ScanMag2*1 ScanPhase2 + (27*ScanPhaseShiftA + 28*ScanPhaseShiftB)
  2:1110: ScanMag2*1 ScanPhase2 + (27*ScanPhaseShiftA + 29*ScanPhaseShiftB)
  2:1111: ScanMag2*1 ScanPhase2 + (27*ScanPhaseShiftA + 30*ScanPhaseShiftB)
  2:1112: ScanMag2*1 ScanPhase2 + (27*ScanPhaseShiftA + 31*ScanPhaseShiftB)
  2:1113: ScanMag2*1 ScanPhase2 + (27*ScanPhaseShiftA + 32*ScanPhaseShiftB)
  2:1114: ScanMag2*1 ScanPhase2 + (27*ScanPhaseShiftA + 33*ScanPhaseShiftB)
  2:1115: ScanMag2*1 ScanPhase2 + (27*ScanPhaseShiftA + 34*ScanPhaseShiftB)
  2:1116: ScanMag2*1 ScanPhase2 + (27*ScanPhaseShiftA + 35*ScanPhaseShiftB)
  2:1117: ScanMag2*1 ScanPhase2 + (27*ScanPhaseShiftA + 36*ScanPhaseShiftB)
  2:1118: ScanMag2*1 ScanPhase2 + (27*ScanPhaseShiftA + 37*ScanPhaseShiftB)
  2:1119: ScanMag2*1 ScanPhase2 + (27*ScanPhaseShiftA + 38*ScanPhaseShiftB)
  2:1120: ScanMag2*1 ScanPhase2 + (27*ScanPhaseShiftA + 39*ScanPhaseShiftB)
  2:1121: ScanMag2*1 ScanPhase2 + (28*ScanPhaseShiftA + 0*ScanPhaseShiftB)
  2:1122: ScanMag2*1 ScanPhase2 + (28*ScanPhaseShiftA + 1*ScanPhaseShiftB)
  2:1123: ScanMag2*1 ScanPhase2 + (28*ScanPhaseShiftA + 2*ScanPhaseShiftB)
  2:1124: ScanMag2*1 ScanPhase2 + (28*ScanPhaseShiftA + 3*ScanPhaseShiftB)
  2:1125: ScanMag2*1 ScanPhase2 + (28*ScanPhaseShiftA + 4*ScanPhaseShiftB)
  2:1126: ScanMag2*1 ScanPhase2 + (28*ScanPhaseShiftA + 5*ScanPhaseShiftB)
  2:1127: ScanMag2*1 ScanPhase2 + (28*ScanPhaseShiftA + 6*ScanPhaseShiftB)
  2:1128: ScanMag2*1 ScanPhase2 + (28*ScanPhaseShiftA + 7*ScanPhaseShiftB)
  2:1129: ScanMag2*1 ScanPhase2 + (28*ScanPhaseShiftA + 8*ScanPhaseShiftB)
  2:1130: ScanMag2*1 ScanPhase2 + (28*ScanPhaseShiftA + 9*ScanPhaseShiftB)
  2:1131: ScanMag2*1 ScanPhase2 + (28*ScanPhaseShiftA + 10*ScanPhaseShiftB)
  2:1132: ScanMag2*1 ScanPhase2 + (28*ScanPhaseShiftA + 11*ScanPhaseShiftB)
  2:1133: ScanMag2*1 ScanPhase2 + (28*ScanPhaseShiftA + 12*ScanPhaseShiftB)
  2:1134: ScanMag2*1 ScanPhase2 + (28*ScanPhaseShiftA + 13*ScanPhaseShiftB)
  2:1135: ScanMag2*1 ScanPhase2 + (28*ScanPhaseShiftA + 14*ScanPhaseShiftB)
  2:1136: ScanMag2*1 ScanPhase2 + (28*ScanPhaseShiftA + 15*ScanPhaseShiftB)
  2:1137: ScanMag2*1 ScanPhase2 + (28*ScanPhaseShiftA + 16*ScanPhaseShiftB)
  2:1138: ScanMag2*1 ScanPhase2 + (28*ScanPhaseShiftA + 17*ScanPhaseShiftB)
  2:1139: ScanMag2*1 ScanPhase2 + (28*ScanPhaseShiftA + 18*ScanPhaseShiftB)
  2:1140: ScanMag2*1 ScanPhase2 + (28*ScanPhaseShiftA + 19*ScanPhaseShiftB)
  2:1141: ScanMag2*1 ScanPhase2 + (28*ScanPhaseShiftA + 20*ScanPhaseShiftB)
  2:1142: ScanMag2*1 ScanPhase2 + (28*ScanPhaseShiftA + 21*ScanPhaseShiftB)
  2:1143: ScanMag2*1 ScanPhase2 + (28*ScanPhaseShiftA + 22*ScanPhaseShiftB)
  2:1144: ScanMag2*1 ScanPhase2 + (28*ScanPhaseShiftA + 23*ScanPhaseShiftB)
  2:1145: ScanMag2*1 ScanPhase2 + (28*ScanPhaseShiftA + 24*ScanPhaseShiftB)
  2:1146: ScanMag2*1 ScanPhase2 + (28*ScanPhaseShiftA + 25*ScanPhaseShiftB)
  2:1147: ScanMag2*1 ScanPhase2 + (28*ScanPhaseShiftA + 26*ScanPhaseShiftB)
  2:1148: ScanMag2*1 ScanPhase2 + (28*ScanPhaseShiftA + 27*ScanPhaseShiftB)
  2:1149: ScanMag2*1 ScanPhase2 + (28*ScanPhaseShiftA + 28*ScanPhaseShiftB)
  2:1150: ScanMag2*1 ScanPhase2 + (28*ScanPhaseShiftA + 29*ScanPhaseShiftB)
  2:1151: ScanMag2*1 ScanPhase2 + (28*ScanPhaseShiftA + 30*ScanPhaseShiftB)
  2:1152: ScanMag2*1 ScanPhase2 + (28*ScanPhaseShiftA + 31*ScanPhaseShiftB)
  2:1153: ScanMag2*1 ScanPhase2 + (28*ScanPhaseShiftA + 32*ScanPhaseShiftB)
  2:1154: ScanMag2*1 ScanPhase2 + (28*ScanPhaseShiftA + 33*ScanPhaseShiftB)
  2:1155: ScanMag2*1 ScanPhase2 + (28*ScanPhaseShiftA + 34*ScanPhaseShiftB)
  2:1156: ScanMag2*1 ScanPhase2 + (28*ScanPhaseShiftA + 35*ScanPhaseShiftB)
  2:1157: ScanMag2*1 ScanPhase2 + (28*ScanPhaseShiftA + 36*ScanPhaseShiftB)
  2:1158: ScanMag2*1 ScanPhase2 + (28*ScanPhaseShiftA + 37*ScanPhaseShiftB)
  2:1159: ScanMag2*1 ScanPhase2 + (28*ScanPhaseShiftA + 38*ScanPhaseShiftB)
  2:1160: ScanMag2*1 ScanPhase2 + (28*ScanPhaseShiftA + 39*ScanPhaseShiftB)
  2:1161: ScanMag2*1 ScanPhase2 + (29*ScanPhaseShiftA + 0*ScanPhaseShiftB)
  2:1162: ScanMag2*1 ScanPhase2 + (29*ScanPhaseShiftA + 1*ScanPhaseShiftB)
  2:1163: ScanMag2*1 ScanPhase2 + (29*ScanPhaseShiftA + 2*ScanPhaseShiftB)
  2:1164: ScanMag2*1 ScanPhase2 + (29*ScanPhaseShiftA + 3*ScanPhaseShiftB)
  2:1165: ScanMag2*1 ScanPhase2 + (29*ScanPhaseShiftA + 4*ScanPhaseShiftB)
  2:1166: ScanMag2*1 ScanPhase2 + (29*ScanPhaseShiftA + 5*ScanPhaseShiftB)
  2:1167: ScanMag2*1 ScanPhase2 + (29*ScanPhaseShiftA + 6*ScanPhaseShiftB)
  2:1168: ScanMag2*1 ScanPhase2 + (29*ScanPhaseShiftA + 7*ScanPhaseShiftB)
  2:1169: ScanMag2*1 ScanPhase2 + (29*ScanPhaseShiftA + 8*ScanPhaseShiftB)
  2:1170: ScanMag2*1 ScanPhase2 + (29*ScanPhaseShiftA + 9*ScanPhaseShiftB)
  2:1171: ScanMag2*1 ScanPhase2 + (29*ScanPhaseShiftA + 10*ScanPhaseShiftB)
  2:1172: ScanMag2*1 ScanPhase2 + (29*ScanPhaseShiftA + 11*ScanPhaseShiftB)
  2:1173: ScanMag2*1 ScanPhase2 + (29*ScanPhaseShiftA + 12*ScanPhaseShiftB)
  2:1174: ScanMag2*1 ScanPhase2 + (29*ScanPhaseShiftA + 13*ScanPhaseShiftB)
  2:1175: ScanMag2*1 ScanPhase2 + (29*ScanPhaseShiftA + 14*ScanPhaseShiftB)
  2:1176: ScanMag2*1 ScanPhase2 + (29*ScanPhaseShiftA + 15*ScanPhaseShiftB)
  2:1177: ScanMag2*1 ScanPhase2 + (29*ScanPhaseShiftA + 16*ScanPhaseShiftB)
  2:1178: ScanMag2*1 ScanPhase2 + (29*ScanPhaseShiftA + 17*ScanPhaseShiftB)
  2:1179: ScanMag2*1 ScanPhase2 + (29*ScanPhaseShiftA + 18*ScanPhaseShiftB)
  2:1180: ScanMag2*1 ScanPhase2 + (29*ScanPhaseShiftA + 19*ScanPhaseShiftB)
  2:1181: ScanMag2*1 ScanPhase2 + (29*ScanPhaseShiftA + 20*ScanPhaseShiftB)
  2:1182: ScanMag2*1 ScanPhase2 + (29*ScanPhaseShiftA + 21*ScanPhaseShiftB)
  2:1183: ScanMag2*1 ScanPhase2 + (29*ScanPhaseShiftA + 22*ScanPhaseShiftB)
  2:1184: ScanMag2*1 ScanPhase2 + (29*ScanPhaseShiftA + 23*ScanPhaseShiftB)
  2:1185: ScanMag2*1 ScanPhase2 + (29*ScanPhaseShiftA + 24*ScanPhaseShiftB)
  2:1186: ScanMag2*1 ScanPhase2 + (29*ScanPhaseShiftA + 25*ScanPhaseShiftB)
  2:1187: ScanMag2*1 ScanPhase2 + (29*ScanPhaseShiftA + 26*ScanPhaseShiftB)
  2:1188: ScanMag2*1 ScanPhase2 + (29*ScanPhaseShiftA + 27*ScanPhaseShiftB)
  2:1189: ScanMag2*1 ScanPhase2 + (29*ScanPhaseShiftA + 28*ScanPhaseShiftB)
  2:1190: ScanMag2*1 ScanPhase2 + (29*ScanPhaseShiftA + 29*ScanPhaseShiftB)
  2:1191: ScanMag2*1 ScanPhase2 + (29*ScanPhaseShiftA + 30*ScanPhaseShiftB)
  2:1192: ScanMag2*1 ScanPhase2 + (29*ScanPhaseShiftA + 31*ScanPhaseShiftB)
  2:1193: ScanMag2*1 ScanPhase2 + (29*ScanPhaseShiftA + 32*ScanPhaseShiftB)
  2:1194: ScanMag2*1 ScanPhase2 + (29*ScanPhaseShiftA + 33*ScanPhaseShiftB)
  2:1195: ScanMag2*1 ScanPhase2 + (29*ScanPhaseShiftA + 34*ScanPhaseShiftB)
  2:1196: ScanMag2*1 ScanPhase2 + (29*ScanPhaseShiftA + 35*ScanPhaseShiftB)
  2:1197: ScanMag2*1 ScanPhase2 + (29*ScanPhaseShiftA + 36*ScanPhaseShiftB)
  2:1198: ScanMag2*1 ScanPhase2 + (29*ScanPhaseShiftA + 37*ScanPhaseShiftB)
  2:1199: ScanMag2*1 ScanPhase2 + (29*ScanPhaseShiftA + 38*ScanPhaseShiftB)
  2:1200: ScanMag2*1 ScanPhase2 + (29*ScanPhaseShiftA + 39*ScanPhaseShiftB)
  2:1201: ScanMag2*1 ScanPhase2 + (30*ScanPhaseShiftA + 0*ScanPhaseShiftB)
  2:1202: ScanMag2*1 ScanPhase2 + (30*ScanPhaseShiftA + 1*ScanPhaseShiftB)
  2:1203: ScanMag2*1 ScanPhase2 + (30*ScanPhaseShiftA + 2*ScanPhaseShiftB)
  2:1204: ScanMag2*1 ScanPhase2 + (30*ScanPhaseShiftA + 3*ScanPhaseShiftB)
  2:1205: ScanMag2*1 ScanPhase2 + (30*ScanPhaseShiftA + 4*ScanPhaseShiftB)
  2:1206: ScanMag2*1 ScanPhase2 + (30*ScanPhaseShiftA + 5*ScanPhaseShiftB)
  2:1207: ScanMag2*1 ScanPhase2 + (30*ScanPhaseShiftA + 6*ScanPhaseShiftB)
  2:1208: ScanMag2*1 ScanPhase2 + (30*ScanPhaseShiftA + 7*ScanPhaseShiftB)
  2:1209: ScanMag2*1 ScanPhase2 + (30*ScanPhaseShiftA + 8*ScanPhaseShiftB)
  2:1210: ScanMag2*1 ScanPhase2 + (30*ScanPhaseShiftA + 9*ScanPhaseShiftB)
  2:1211: ScanMag2*1 ScanPhase2 + (30*ScanPhaseShiftA + 10*ScanPhaseShiftB)
  2:1212: ScanMag2*1 ScanPhase2 + (30*ScanPhaseShiftA + 11*ScanPhaseShiftB)
  2:1213: ScanMag2*1 ScanPhase2 + (30*ScanPhaseShiftA + 12*ScanPhaseShiftB)
  2:1214: ScanMag2*1 ScanPhase2 + (30*ScanPhaseShiftA + 13*ScanPhaseShiftB)
  2:1215: ScanMag2*1 ScanPhase2 + (30*ScanPhaseShiftA + 14*ScanPhaseShiftB)
  2:1216: ScanMag2*1 ScanPhase2 + (30*ScanPhaseShiftA + 15*ScanPhaseShiftB)
  2:1217: ScanMag2*1 ScanPhase2 + (30*ScanPhaseShiftA + 16*ScanPhaseShiftB)
  2:1218: ScanMag2*1 ScanPhase2 + (30*ScanPhaseShiftA + 17*ScanPhaseShiftB)
  2:1219: ScanMag2*1 ScanPhase2 + (30*ScanPhaseShiftA + 18*ScanPhaseShiftB)
  2:1220: ScanMag2*1 ScanPhase2 + (30*ScanPhaseShiftA + 19*ScanPhaseShiftB)
  2:1221: ScanMag2*1 ScanPhase2 + (30*ScanPhaseShiftA + 20*ScanPhaseShiftB)
  2:1222: ScanMag2*1 ScanPhase2 + (30*ScanPhaseShiftA + 21*ScanPhaseShiftB)
  2:1223: ScanMag2*1 ScanPhase2 + (30*ScanPhaseShiftA + 22*ScanPhaseShiftB)
  2:1224: ScanMag2*1 ScanPhase2 + (30*ScanPhaseShiftA + 23*ScanPhaseShiftB)
  2:1225: ScanMag2*1 ScanPhase2 + (30*ScanPhaseShiftA + 24*ScanPhaseShiftB)
  2:1226: ScanMag2*1 ScanPhase2 + (30*ScanPhaseShiftA + 25*ScanPhaseShiftB)
  2:1227: ScanMag2*1 ScanPhase2 + (30*ScanPhaseShiftA + 26*ScanPhaseShiftB)
  2:1228: ScanMag2*1 ScanPhase2 + (30*ScanPhaseShiftA + 27*ScanPhaseShiftB)
  2:1229: ScanMag2*1 ScanPhase2 + (30*ScanPhaseShiftA + 28*ScanPhaseShiftB)
  2:1230: ScanMag2*1 ScanPhase2 + (30*ScanPhaseShiftA + 29*ScanPhaseShiftB)
  2:1231: ScanMag2*1 ScanPhase2 + (30*ScanPhaseShiftA + 30*ScanPhaseShiftB)
  2:1232: ScanMag2*1 ScanPhase2 + (30*ScanPhaseShiftA + 31*ScanPhaseShiftB)
  2:1233: ScanMag2*1 ScanPhase2 + (30*ScanPhaseShiftA + 32*ScanPhaseShiftB)
  2:1234: ScanMag2*1 ScanPhase2 + (30*ScanPhaseShiftA + 33*ScanPhaseShiftB)
  2:1235: ScanMag2*1 ScanPhase2 + (30*ScanPhaseShiftA + 34*ScanPhaseShiftB)
  2:1236: ScanMag2*1 ScanPhase2 + (30*ScanPhaseShiftA + 35*ScanPhaseShiftB)
  2:1237: ScanMag2*1 ScanPhase2 + (30*ScanPhaseShiftA + 36*ScanPhaseShiftB)
  2:1238: ScanMag2*1 ScanPhase2 + (30*ScanPhaseShiftA + 37*ScanPhaseShiftB)
  2:1239: ScanMag2*1 ScanPhase2 + (30*ScanPhaseShiftA + 38*ScanPhaseShiftB)
  2:1240: ScanMag2*1 ScanPhase2 + (30*ScanPhaseShiftA + 39*ScanPhaseShiftB)
  2:1241: ScanMag2*1 ScanPhase2 + (31*ScanPhaseShiftA + 0*ScanPhaseShiftB)
  2:1242: ScanMag2*1 ScanPhase2 + (31*ScanPhaseShiftA + 1*ScanPhaseShiftB)
  2:1243: ScanMag2*1 ScanPhase2 + (31*ScanPhaseShiftA + 2*ScanPhaseShiftB)
  2:1244: ScanMag2*1 ScanPhase2 + (31*ScanPhaseShiftA + 3*ScanPhaseShiftB)
  2:1245: ScanMag2*1 ScanPhase2 + (31*ScanPhaseShiftA + 4*ScanPhaseShiftB)
  2:1246: ScanMag2*1 ScanPhase2 + (31*ScanPhaseShiftA + 5*ScanPhaseShiftB)
  2:1247: ScanMag2*1 ScanPhase2 + (31*ScanPhaseShiftA + 6*ScanPhaseShiftB)
  2:1248: ScanMag2*1 ScanPhase2 + (31*ScanPhaseShiftA + 7*ScanPhaseShiftB)
  2:1249: ScanMag2*1 ScanPhase2 + (31*ScanPhaseShiftA + 8*ScanPhaseShiftB)
  2:1250: ScanMag2*1 ScanPhase2 + (31*ScanPhaseShiftA + 9*ScanPhaseShiftB)
  2:1251: ScanMag2*1 ScanPhase2 + (31*ScanPhaseShiftA + 10*ScanPhaseShiftB)
  2:1252: ScanMag2*1 ScanPhase2 + (31*ScanPhaseShiftA + 11*ScanPhaseShiftB)
  2:1253: ScanMag2*1 ScanPhase2 + (31*ScanPhaseShiftA + 12*ScanPhaseShiftB)
  2:1254: ScanMag2*1 ScanPhase2 + (31*ScanPhaseShiftA + 13*ScanPhaseShiftB)
  2:1255: ScanMag2*1 ScanPhase2 + (31*ScanPhaseShiftA + 14*ScanPhaseShiftB)
  2:1256: ScanMag2*1 ScanPhase2 + (31*ScanPhaseShiftA + 15*ScanPhaseShiftB)
  2:1257: ScanMag2*1 ScanPhase2 + (31*ScanPhaseShiftA + 16*ScanPhaseShiftB)
  2:1258: ScanMag2*1 ScanPhase2 + (31*ScanPhaseShiftA + 17*ScanPhaseShiftB)
  2:1259: ScanMag2*1 ScanPhase2 + (31*ScanPhaseShiftA + 18*ScanPhaseShiftB)
  2:1260: ScanMag2*1 ScanPhase2 + (31*ScanPhaseShiftA + 19*ScanPhaseShiftB)
  2:1261: ScanMag2*1 ScanPhase2 + (31*ScanPhaseShiftA + 20*ScanPhaseShiftB)
  2:1262: ScanMag2*1 ScanPhase2 + (31*ScanPhaseShiftA + 21*ScanPhaseShiftB)
  2:1263: ScanMag2*1 ScanPhase2 + (31*ScanPhaseShiftA + 22*ScanPhaseShiftB)
  2:1264: ScanMag2*1 ScanPhase2 + (31*ScanPhaseShiftA + 23*ScanPhaseShiftB)
  2:1265: ScanMag2*1 ScanPhase2 + (31*ScanPhaseShiftA + 24*ScanPhaseShiftB)
  2:1266: ScanMag2*1 ScanPhase2 + (31*ScanPhaseShiftA + 25*ScanPhaseShiftB)
  2:1267: ScanMag2*1 ScanPhase2 + (31*ScanPhaseShiftA + 26*ScanPhaseShiftB)
  2:1268: ScanMag2*1 ScanPhase2 + (31*ScanPhaseShiftA + 27*ScanPhaseShiftB)
  2:1269: ScanMag2*1 ScanPhase2 + (31*ScanPhaseShiftA + 28*ScanPhaseShiftB)
  2:1270: ScanMag2*1 ScanPhase2 + (31*ScanPhaseShiftA + 29*ScanPhaseShiftB)
  2:1271: ScanMag2*1 ScanPhase2 + (31*ScanPhaseShiftA + 30*ScanPhaseShiftB)
  2:1272: ScanMag2*1 ScanPhase2 + (31*ScanPhaseShiftA + 31*ScanPhaseShiftB)
  2:1273: ScanMag2*1 ScanPhase2 + (31*ScanPhaseShiftA + 32*ScanPhaseShiftB)
  2:1274: ScanMag2*1 ScanPhase2 + (31*ScanPhaseShiftA + 33*ScanPhaseShiftB)
  2:1275: ScanMag2*1 ScanPhase2 + (31*ScanPhaseShiftA + 34*ScanPhaseShiftB)
  2:1276: ScanMag2*1 ScanPhase2 + (31*ScanPhaseShiftA + 35*ScanPhaseShiftB)
  2:1277: ScanMag2*1 ScanPhase2 + (31*ScanPhaseShiftA + 36*ScanPhaseShiftB)
  2:1278: ScanMag2*1 ScanPhase2 + (31*ScanPhaseShiftA + 37*ScanPhaseShiftB)
  2:1279: ScanMag2*1 ScanPhase2 + (31*ScanPhaseShiftA + 38*ScanPhaseShiftB)
  2:1280: ScanMag2*1 ScanPhase2 + (31*ScanPhaseShiftA + 39*ScanPhaseShiftB)
  2:1281: ScanMag2*1 ScanPhase2 + (32*ScanPhaseShiftA + 0*ScanPhaseShiftB)
  2:1282: ScanMag2*1 ScanPhase2 + (32*ScanPhaseShiftA + 1*ScanPhaseShiftB)
  2:1283: ScanMag2*1 ScanPhase2 + (32*ScanPhaseShiftA + 2*ScanPhaseShiftB)
  2:1284: ScanMag2*1 ScanPhase2 + (32*ScanPhaseShiftA + 3*ScanPhaseShiftB)
  2:1285: ScanMag2*1 ScanPhase2 + (32*ScanPhaseShiftA + 4*ScanPhaseShiftB)
  2:1286: ScanMag2*1 ScanPhase2 + (32*ScanPhaseShiftA + 5*ScanPhaseShiftB)
  2:1287: ScanMag2*1 ScanPhase2 + (32*ScanPhaseShiftA + 6*ScanPhaseShiftB)
  2:1288: ScanMag2*1 ScanPhase2 + (32*ScanPhaseShiftA + 7*ScanPhaseShiftB)
  2:1289: ScanMag2*1 ScanPhase2 + (32*ScanPhaseShiftA + 8*ScanPhaseShiftB)
  2:1290: ScanMag2*1 ScanPhase2 + (32*ScanPhaseShiftA + 9*ScanPhaseShiftB)
  2:1291: ScanMag2*1 ScanPhase2 + (32*ScanPhaseShiftA + 10*ScanPhaseShiftB)
  2:1292: ScanMag2*1 ScanPhase2 + (32*ScanPhaseShiftA + 11*ScanPhaseShiftB)
  2:1293: ScanMag2*1 ScanPhase2 + (32*ScanPhaseShiftA + 12*ScanPhaseShiftB)
  2:1294: ScanMag2*1 ScanPhase2 + (32*ScanPhaseShiftA + 13*ScanPhaseShiftB)
  2:1295: ScanMag2*1 ScanPhase2 + (32*ScanPhaseShiftA + 14*ScanPhaseShiftB)
  2:1296: ScanMag2*1 ScanPhase2 + (32*ScanPhaseShiftA + 15*ScanPhaseShiftB)
  2:1297: ScanMag2*1 ScanPhase2 + (32*ScanPhaseShiftA + 16*ScanPhaseShiftB)
  2:1298: ScanMag2*1 ScanPhase2 + (32*ScanPhaseShiftA + 17*ScanPhaseShiftB)
  2:1299: ScanMag2*1 ScanPhase2 + (32*ScanPhaseShiftA + 18*ScanPhaseShiftB)
  2:1300: ScanMag2*1 ScanPhase2 + (32*ScanPhaseShiftA + 19*ScanPhaseShiftB)
  2:1301: ScanMag2*1 ScanPhase2 + (32*ScanPhaseShiftA + 20*ScanPhaseShiftB)
  2:1302: ScanMag2*1 ScanPhase2 + (32*ScanPhaseShiftA + 21*ScanPhaseShiftB)
  2:1303: ScanMag2*1 ScanPhase2 + (32*ScanPhaseShiftA + 22*ScanPhaseShiftB)
  2:1304: ScanMag2*1 ScanPhase2 + (32*ScanPhaseShiftA + 23*ScanPhaseShiftB)
  2:1305: ScanMag2*1 ScanPhase2 + (32*ScanPhaseShiftA + 24*ScanPhaseShiftB)
  2:1306: ScanMag2*1 ScanPhase2 + (32*ScanPhaseShiftA + 25*ScanPhaseShiftB)
  2:1307: ScanMag2*1 ScanPhase2 + (32*ScanPhaseShiftA + 26*ScanPhaseShiftB)
  2:1308: ScanMag2*1 ScanPhase2 + (32*ScanPhaseShiftA + 27*ScanPhaseShiftB)
  2:1309: ScanMag2*1 ScanPhase2 + (32*ScanPhaseShiftA + 28*ScanPhaseShiftB)
  2:1310: ScanMag2*1 ScanPhase2 + (32*ScanPhaseShiftA + 29*ScanPhaseShiftB)
  2:1311: ScanMag2*1 ScanPhase2 + (32*ScanPhaseShiftA + 30*ScanPhaseShiftB)
  2:1312: ScanMag2*1 ScanPhase2 + (32*ScanPhaseShiftA + 31*ScanPhaseShiftB)
  2:1313: ScanMag2*1 ScanPhase2 + (32*ScanPhaseShiftA + 32*ScanPhaseShiftB)
  2:1314: ScanMag2*1 ScanPhase2 + (32*ScanPhaseShiftA + 33*ScanPhaseShiftB)
  2:1315: ScanMag2*1 ScanPhase2 + (32*ScanPhaseShiftA + 34*ScanPhaseShiftB)
  2:1316: ScanMag2*1 ScanPhase2 + (32*ScanPhaseShiftA + 35*ScanPhaseShiftB)
  2:1317: ScanMag2*1 ScanPhase2 + (32*ScanPhaseShiftA + 36*ScanPhaseShiftB)
  2:1318: ScanMag2*1 ScanPhase2 + (32*ScanPhaseShiftA + 37*ScanPhaseShiftB)
  2:1319: ScanMag2*1 ScanPhase2 + (32*ScanPhaseShiftA + 38*ScanPhaseShiftB)
  2:1320: ScanMag2*1 ScanPhase2 + (32*ScanPhaseShiftA + 39*ScanPhaseShiftB)
  2:1321: ScanMag2*1 ScanPhase2 + (33*ScanPhaseShiftA + 0*ScanPhaseShiftB)
  2:1322: ScanMag2*1 ScanPhase2 + (33*ScanPhaseShiftA + 1*ScanPhaseShiftB)
  2:1323: ScanMag2*1 ScanPhase2 + (33*ScanPhaseShiftA + 2*ScanPhaseShiftB)
  2:1324: ScanMag2*1 ScanPhase2 + (33*ScanPhaseShiftA + 3*ScanPhaseShiftB)
  2:1325: ScanMag2*1 ScanPhase2 + (33*ScanPhaseShiftA + 4*ScanPhaseShiftB)
  2:1326: ScanMag2*1 ScanPhase2 + (33*ScanPhaseShiftA + 5*ScanPhaseShiftB)
  2:1327: ScanMag2*1 ScanPhase2 + (33*ScanPhaseShiftA + 6*ScanPhaseShiftB)
  2:1328: ScanMag2*1 ScanPhase2 + (33*ScanPhaseShiftA + 7*ScanPhaseShiftB)
  2:1329: ScanMag2*1 ScanPhase2 + (33*ScanPhaseShiftA + 8*ScanPhaseShiftB)
  2:1330: ScanMag2*1 ScanPhase2 + (33*ScanPhaseShiftA + 9*ScanPhaseShiftB)
  2:1331: ScanMag2*1 ScanPhase2 + (33*ScanPhaseShiftA + 10*ScanPhaseShiftB)
  2:1332: ScanMag2*1 ScanPhase2 + (33*ScanPhaseShiftA + 11*ScanPhaseShiftB)
  2:1333: ScanMag2*1 ScanPhase2 + (33*ScanPhaseShiftA + 12*ScanPhaseShiftB)
  2:1334: ScanMag2*1 ScanPhase2 + (33*ScanPhaseShiftA + 13*ScanPhaseShiftB)
  2:1335: ScanMag2*1 ScanPhase2 + (33*ScanPhaseShiftA + 14*ScanPhaseShiftB)
  2:1336: ScanMag2*1 ScanPhase2 + (33*ScanPhaseShiftA + 15*ScanPhaseShiftB)
  2:1337: ScanMag2*1 ScanPhase2 + (33*ScanPhaseShiftA + 16*ScanPhaseShiftB)
  2:1338: ScanMag2*1 ScanPhase2 + (33*ScanPhaseShiftA + 17*ScanPhaseShiftB)
  2:1339: ScanMag2*1 ScanPhase2 + (33*ScanPhaseShiftA + 18*ScanPhaseShiftB)
  2:1340: ScanMag2*1 ScanPhase2 + (33*ScanPhaseShiftA + 19*ScanPhaseShiftB)
  2:1341: ScanMag2*1 ScanPhase2 + (33*ScanPhaseShiftA + 20*ScanPhaseShiftB)
  2:1342: ScanMag2*1 ScanPhase2 + (33*ScanPhaseShiftA + 21*ScanPhaseShiftB)
  2:1343: ScanMag2*1 ScanPhase2 + (33*ScanPhaseShiftA + 22*ScanPhaseShiftB)
  2:1344: ScanMag2*1 ScanPhase2 + (33*ScanPhaseShiftA + 23*ScanPhaseShiftB)
  2:1345: ScanMag2*1 ScanPhase2 + (33*ScanPhaseShiftA + 24*ScanPhaseShiftB)
  2:1346: ScanMag2*1 ScanPhase2 + (33*ScanPhaseShiftA + 25*ScanPhaseShiftB)
  2:1347: ScanMag2*1 ScanPhase2 + (33*ScanPhaseShiftA + 26*ScanPhaseShiftB)
  2:1348: ScanMag2*1 ScanPhase2 + (33*ScanPhaseShiftA + 27*ScanPhaseShiftB)
  2:1349: ScanMag2*1 ScanPhase2 + (33*ScanPhaseShiftA + 28*ScanPhaseShiftB)
  2:1350: ScanMag2*1 ScanPhase2 + (33*ScanPhaseShiftA + 29*ScanPhaseShiftB)
  2:1351: ScanMag2*1 ScanPhase2 + (33*ScanPhaseShiftA + 30*ScanPhaseShiftB)
  2:1352: ScanMag2*1 ScanPhase2 + (33*ScanPhaseShiftA + 31*ScanPhaseShiftB)
  2:1353: ScanMag2*1 ScanPhase2 + (33*ScanPhaseShiftA + 32*ScanPhaseShiftB)
  2:1354: ScanMag2*1 ScanPhase2 + (33*ScanPhaseShiftA + 33*ScanPhaseShiftB)
  2:1355: ScanMag2*1 ScanPhase2 + (33*ScanPhaseShiftA + 34*ScanPhaseShiftB)
  2:1356: ScanMag2*1 ScanPhase2 + (33*ScanPhaseShiftA + 35*ScanPhaseShiftB)
  2:1357: ScanMag2*1 ScanPhase2 + (33*ScanPhaseShiftA + 36*ScanPhaseShiftB)
  2:1358: ScanMag2*1 ScanPhase2 + (33*ScanPhaseShiftA + 37*ScanPhaseShiftB)
  2:1359: ScanMag2*1 ScanPhase2 + (33*ScanPhaseShiftA + 38*ScanPhaseShiftB)
  2:1360: ScanMag2*1 ScanPhase2 + (33*ScanPhaseShiftA + 39*ScanPhaseShiftB)
  2:1361: ScanMag2*1 ScanPhase2 + (34*ScanPhaseShiftA + 0*ScanPhaseShiftB)
  2:1362: ScanMag2*1 ScanPhase2 + (34*ScanPhaseShiftA + 1*ScanPhaseShiftB)
  2:1363: ScanMag2*1 ScanPhase2 + (34*ScanPhaseShiftA + 2*ScanPhaseShiftB)
  2:1364: ScanMag2*1 ScanPhase2 + (34*ScanPhaseShiftA + 3*ScanPhaseShiftB)
  2:1365: ScanMag2*1 ScanPhase2 + (34*ScanPhaseShiftA + 4*ScanPhaseShiftB)
  2:1366: ScanMag2*1 ScanPhase2 + (34*ScanPhaseShiftA + 5*ScanPhaseShiftB)
  2:1367: ScanMag2*1 ScanPhase2 + (34*ScanPhaseShiftA + 6*ScanPhaseShiftB)
  2:1368: ScanMag2*1 ScanPhase2 + (34*ScanPhaseShiftA + 7*ScanPhaseShiftB)
  2:1369: ScanMag2*1 ScanPhase2 + (34*ScanPhaseShiftA + 8*ScanPhaseShiftB)
  2:1370: ScanMag2*1 ScanPhase2 + (34*ScanPhaseShiftA + 9*ScanPhaseShiftB)
  2:1371: ScanMag2*1 ScanPhase2 + (34*ScanPhaseShiftA + 10*ScanPhaseShiftB)
  2:1372: ScanMag2*1 ScanPhase2 + (34*ScanPhaseShiftA + 11*ScanPhaseShiftB)
  2:1373: ScanMag2*1 ScanPhase2 + (34*ScanPhaseShiftA + 12*ScanPhaseShiftB)
  2:1374: ScanMag2*1 ScanPhase2 + (34*ScanPhaseShiftA + 13*ScanPhaseShiftB)
  2:1375: ScanMag2*1 ScanPhase2 + (34*ScanPhaseShiftA + 14*ScanPhaseShiftB)
  2:1376: ScanMag2*1 ScanPhase2 + (34*ScanPhaseShiftA + 15*ScanPhaseShiftB)
  2:1377: ScanMag2*1 ScanPhase2 + (34*ScanPhaseShiftA + 16*ScanPhaseShiftB)
  2:1378: ScanMag2*1 ScanPhase2 + (34*ScanPhaseShiftA + 17*ScanPhaseShiftB)
  2:1379: ScanMag2*1 ScanPhase2 + (34*ScanPhaseShiftA + 18*ScanPhaseShiftB)
  2:1380: ScanMag2*1 ScanPhase2 + (34*ScanPhaseShiftA + 19*ScanPhaseShiftB)
  2:1381: ScanMag2*1 ScanPhase2 + (34*ScanPhaseShiftA + 20*ScanPhaseShiftB)
  2:1382: ScanMag2*1 ScanPhase2 + (34*ScanPhaseShiftA + 21*ScanPhaseShiftB)
  2:1383: ScanMag2*1 ScanPhase2 + (34*ScanPhaseShiftA + 22*ScanPhaseShiftB)
  2:1384: ScanMag2*1 ScanPhase2 + (34*ScanPhaseShiftA + 23*ScanPhaseShiftB)
  2:1385: ScanMag2*1 ScanPhase2 + (34*ScanPhaseShiftA + 24*ScanPhaseShiftB)
  2:1386: ScanMag2*1 ScanPhase2 + (34*ScanPhaseShiftA + 25*ScanPhaseShiftB)
  2:1387: ScanMag2*1 ScanPhase2 + (34*ScanPhaseShiftA + 26*ScanPhaseShiftB)
  2:1388: ScanMag2*1 ScanPhase2 + (34*ScanPhaseShiftA + 27*ScanPhaseShiftB)
  2:1389: ScanMag2*1 ScanPhase2 + (34*ScanPhaseShiftA + 28*ScanPhaseShiftB)
  2:1390: ScanMag2*1 ScanPhase2 + (34*ScanPhaseShiftA + 29*ScanPhaseShiftB)
  2:1391: ScanMag2*1 ScanPhase2 + (34*ScanPhaseShiftA + 30*ScanPhaseShiftB)
  2:1392: ScanMag2*1 ScanPhase2 + (34*ScanPhaseShiftA + 31*ScanPhaseShiftB)
  2:1393: ScanMag2*1 ScanPhase2 + (34*ScanPhaseShiftA + 32*ScanPhaseShiftB)
  2:1394: ScanMag2*1 ScanPhase2 + (34*ScanPhaseShiftA + 33*ScanPhaseShiftB)
  2:1395: ScanMag2*1 ScanPhase2 + (34*ScanPhaseShiftA + 34*ScanPhaseShiftB)
  2:1396: ScanMag2*1 ScanPhase2 + (34*ScanPhaseShiftA + 35*ScanPhaseShiftB)
  2:1397: ScanMag2*1 ScanPhase2 + (34*ScanPhaseShiftA + 36*ScanPhaseShiftB)
  2:1398: ScanMag2*1 ScanPhase2 + (34*ScanPhaseShiftA + 37*ScanPhaseShiftB)
  2:1399: ScanMag2*1 ScanPhase2 + (34*ScanPhaseShiftA + 38*ScanPhaseShiftB)
  2:1400: ScanMag2*1 ScanPhase2 + (34*ScanPhaseShiftA + 39*ScanPhaseShiftB)
  2:1401: ScanMag2*1 ScanPhase2 + (35*ScanPhaseShiftA + 0*ScanPhaseShiftB)
  2:1402: ScanMag2*1 ScanPhase2 + (35*ScanPhaseShiftA + 1*ScanPhaseShiftB)
  2:1403: ScanMag2*1 ScanPhase2 + (35*ScanPhaseShiftA + 2*ScanPhaseShiftB)
  2:1404: ScanMag2*1 ScanPhase2 + (35*ScanPhaseShiftA + 3*ScanPhaseShiftB)
  2:1405: ScanMag2*1 ScanPhase2 + (35*ScanPhaseShiftA + 4*ScanPhaseShiftB)
  2:1406: ScanMag2*1 ScanPhase2 + (35*ScanPhaseShiftA + 5*ScanPhaseShiftB)
  2:1407: ScanMag2*1 ScanPhase2 + (35*ScanPhaseShiftA + 6*ScanPhaseShiftB)
  2:1408: ScanMag2*1 ScanPhase2 + (35*ScanPhaseShiftA + 7*ScanPhaseShiftB)
  2:1409: ScanMag2*1 ScanPhase2 + (35*ScanPhaseShiftA + 8*ScanPhaseShiftB)
  2:1410: ScanMag2*1 ScanPhase2 + (35*ScanPhaseShiftA + 9*ScanPhaseShiftB)
  2:1411: ScanMag2*1 ScanPhase2 + (35*ScanPhaseShiftA + 10*ScanPhaseShiftB)
  2:1412: ScanMag2*1 ScanPhase2 + (35*ScanPhaseShiftA + 11*ScanPhaseShiftB)
  2:1413: ScanMag2*1 ScanPhase2 + (35*ScanPhaseShiftA + 12*ScanPhaseShiftB)
  2:1414: ScanMag2*1 ScanPhase2 + (35*ScanPhaseShiftA + 13*ScanPhaseShiftB)
  2:1415: ScanMag2*1 ScanPhase2 + (35*ScanPhaseShiftA + 14*ScanPhaseShiftB)
  2:1416: ScanMag2*1 ScanPhase2 + (35*ScanPhaseShiftA + 15*ScanPhaseShiftB)
  2:1417: ScanMag2*1 ScanPhase2 + (35*ScanPhaseShiftA + 16*ScanPhaseShiftB)
  2:1418: ScanMag2*1 ScanPhase2 + (35*ScanPhaseShiftA + 17*ScanPhaseShiftB)
  2:1419: ScanMag2*1 ScanPhase2 + (35*ScanPhaseShiftA + 18*ScanPhaseShiftB)
  2:1420: ScanMag2*1 ScanPhase2 + (35*ScanPhaseShiftA + 19*ScanPhaseShiftB)
  2:1421: ScanMag2*1 ScanPhase2 + (35*ScanPhaseShiftA + 20*ScanPhaseShiftB)
  2:1422: ScanMag2*1 ScanPhase2 + (35*ScanPhaseShiftA + 21*ScanPhaseShiftB)
  2:1423: ScanMag2*1 ScanPhase2 + (35*ScanPhaseShiftA + 22*ScanPhaseShiftB)
  2:1424: ScanMag2*1 ScanPhase2 + (35*ScanPhaseShiftA + 23*ScanPhaseShiftB)
  2:1425: ScanMag2*1 ScanPhase2 + (35*ScanPhaseShiftA + 24*ScanPhaseShiftB)
  2:1426: ScanMag2*1 ScanPhase2 + (35*ScanPhaseShiftA + 25*ScanPhaseShiftB)
  2:1427: ScanMag2*1 ScanPhase2 + (35*ScanPhaseShiftA + 26*ScanPhaseShiftB)
  2:1428: ScanMag2*1 ScanPhase2 + (35*ScanPhaseShiftA + 27*ScanPhaseShiftB)
  2:1429: ScanMag2*1 ScanPhase2 + (35*ScanPhaseShiftA + 28*ScanPhaseShiftB)
  2:1430: ScanMag2*1 ScanPhase2 + (35*ScanPhaseShiftA + 29*ScanPhaseShiftB)
  2:1431: ScanMag2*1 ScanPhase2 + (35*ScanPhaseShiftA + 30*ScanPhaseShiftB)
  2:1432: ScanMag2*1 ScanPhase2 + (35*ScanPhaseShiftA + 31*ScanPhaseShiftB)
  2:1433: ScanMag2*1 ScanPhase2 + (35*ScanPhaseShiftA + 32*ScanPhaseShiftB)
  2:1434: ScanMag2*1 ScanPhase2 + (35*ScanPhaseShiftA + 33*ScanPhaseShiftB)
  2:1435: ScanMag2*1 ScanPhase2 + (35*ScanPhaseShiftA + 34*ScanPhaseShiftB)
  2:1436: ScanMag2*1 ScanPhase2 + (35*ScanPhaseShiftA + 35*ScanPhaseShiftB)
  2:1437: ScanMag2*1 ScanPhase2 + (35*ScanPhaseShiftA + 36*ScanPhaseShiftB)
  2:1438: ScanMag2*1 ScanPhase2 + (35*ScanPhaseShiftA + 37*ScanPhaseShiftB)
  2:1439: ScanMag2*1 ScanPhase2 + (35*ScanPhaseShiftA + 38*ScanPhaseShiftB)
  2:1440: ScanMag2*1 ScanPhase2 + (35*ScanPhaseShiftA + 39*ScanPhaseShiftB)
  2:1441: ScanMag2*1 ScanPhase2 + (36*ScanPhaseShiftA + 0*ScanPhaseShiftB)
  2:1442: ScanMag2*1 ScanPhase2 + (36*ScanPhaseShiftA + 1*ScanPhaseShiftB)
  2:1443: ScanMag2*1 ScanPhase2 + (36*ScanPhaseShiftA + 2*ScanPhaseShiftB)
  2:1444: ScanMag2*1 ScanPhase2 + (36*ScanPhaseShiftA + 3*ScanPhaseShiftB)
  2:1445: ScanMag2*1 ScanPhase2 + (36*ScanPhaseShiftA + 4*ScanPhaseShiftB)
  2:1446: ScanMag2*1 ScanPhase2 + (36*ScanPhaseShiftA + 5*ScanPhaseShiftB)
  2:1447: ScanMag2*1 ScanPhase2 + (36*ScanPhaseShiftA + 6*ScanPhaseShiftB)
  2:1448: ScanMag2*1 ScanPhase2 + (36*ScanPhaseShiftA + 7*ScanPhaseShiftB)
  2:1449: ScanMag2*1 ScanPhase2 + (36*ScanPhaseShiftA + 8*ScanPhaseShiftB)
  2:1450: ScanMag2*1 ScanPhase2 + (36*ScanPhaseShiftA + 9*ScanPhaseShiftB)
  2:1451: ScanMag2*1 ScanPhase2 + (36*ScanPhaseShiftA + 10*ScanPhaseShiftB)
  2:1452: ScanMag2*1 ScanPhase2 + (36*ScanPhaseShiftA + 11*ScanPhaseShiftB)
  2:1453: ScanMag2*1 ScanPhase2 + (36*ScanPhaseShiftA + 12*ScanPhaseShiftB)
  2:1454: ScanMag2*1 ScanPhase2 + (36*ScanPhaseShiftA + 13*ScanPhaseShiftB)
  2:1455: ScanMag2*1 ScanPhase2 + (36*ScanPhaseShiftA + 14*ScanPhaseShiftB)
  2:1456: ScanMag2*1 ScanPhase2 + (36*ScanPhaseShiftA + 15*ScanPhaseShiftB)
  2:1457: ScanMag2*1 ScanPhase2 + (36*ScanPhaseShiftA + 16*ScanPhaseShiftB)
  2:1458: ScanMag2*1 ScanPhase2 + (36*ScanPhaseShiftA + 17*ScanPhaseShiftB)
  2:1459: ScanMag2*1 ScanPhase2 + (36*ScanPhaseShiftA + 18*ScanPhaseShiftB)
  2:1460: ScanMag2*1 ScanPhase2 + (36*ScanPhaseShiftA + 19*ScanPhaseShiftB)
  2:1461: ScanMag2*1 ScanPhase2 + (36*ScanPhaseShiftA + 20*ScanPhaseShiftB)
  2:1462: ScanMag2*1 ScanPhase2 + (36*ScanPhaseShiftA + 21*ScanPhaseShiftB)
  2:1463: ScanMag2*1 ScanPhase2 + (36*ScanPhaseShiftA + 22*ScanPhaseShiftB)
  2:1464: ScanMag2*1 ScanPhase2 + (36*ScanPhaseShiftA + 23*ScanPhaseShiftB)
  2:1465: ScanMag2*1 ScanPhase2 + (36*ScanPhaseShiftA + 24*ScanPhaseShiftB)
  2:1466: ScanMag2*1 ScanPhase2 + (36*ScanPhaseShiftA + 25*ScanPhaseShiftB)
  2:1467: ScanMag2*1 ScanPhase2 + (36*ScanPhaseShiftA + 26*ScanPhaseShiftB)
  2:1468: ScanMag2*1 ScanPhase2 + (36*ScanPhaseShiftA + 27*ScanPhaseShiftB)
  2:1469: ScanMag2*1 ScanPhase2 + (36*ScanPhaseShiftA + 28*ScanPhaseShiftB)
  2:1470: ScanMag2*1 ScanPhase2 + (36*ScanPhaseShiftA + 29*ScanPhaseShiftB)
  2:1471: ScanMag2*1 ScanPhase2 + (36*ScanPhaseShiftA + 30*ScanPhaseShiftB)
  2:1472: ScanMag2*1 ScanPhase2 + (36*ScanPhaseShiftA + 31*ScanPhaseShiftB)
  2:1473: ScanMag2*1 ScanPhase2 + (36*ScanPhaseShiftA + 32*ScanPhaseShiftB)
  2:1474: ScanMag2*1 ScanPhase2 + (36*ScanPhaseShiftA + 33*ScanPhaseShiftB)
  2:1475: ScanMag2*1 ScanPhase2 + (36*ScanPhaseShiftA + 34*ScanPhaseShiftB)
  2:1476: ScanMag2*1 ScanPhase2 + (36*ScanPhaseShiftA + 35*ScanPhaseShiftB)
  2:1477: ScanMag2*1 ScanPhase2 + (36*ScanPhaseShiftA + 36*ScanPhaseShiftB)
  2:1478: ScanMag2*1 ScanPhase2 + (36*ScanPhaseShiftA + 37*ScanPhaseShiftB)
  2:1479: ScanMag2*1 ScanPhase2 + (36*ScanPhaseShiftA + 38*ScanPhaseShiftB)
  2:1480: ScanMag2*1 ScanPhase2 + (36*ScanPhaseShiftA + 39*ScanPhaseShiftB)
  2:1481: ScanMag2*1 ScanPhase2 + (37*ScanPhaseShiftA + 0*ScanPhaseShiftB)
  2:1482: ScanMag2*1 ScanPhase2 + (37*ScanPhaseShiftA + 1*ScanPhaseShiftB)
  2:1483: ScanMag2*1 ScanPhase2 + (37*ScanPhaseShiftA + 2*ScanPhaseShiftB)
  2:1484: ScanMag2*1 ScanPhase2 + (37*ScanPhaseShiftA + 3*ScanPhaseShiftB)
  2:1485: ScanMag2*1 ScanPhase2 + (37*ScanPhaseShiftA + 4*ScanPhaseShiftB)
  2:1486: ScanMag2*1 ScanPhase2 + (37*ScanPhaseShiftA + 5*ScanPhaseShiftB)
  2:1487: ScanMag2*1 ScanPhase2 + (37*ScanPhaseShiftA + 6*ScanPhaseShiftB)
  2:1488: ScanMag2*1 ScanPhase2 + (37*ScanPhaseShiftA + 7*ScanPhaseShiftB)
  2:1489: ScanMag2*1 ScanPhase2 + (37*ScanPhaseShiftA + 8*ScanPhaseShiftB)
  2:1490: ScanMag2*1 ScanPhase2 + (37*ScanPhaseShiftA + 9*ScanPhaseShiftB)
  2:1491: ScanMag2*1 ScanPhase2 + (37*ScanPhaseShiftA + 10*ScanPhaseShiftB)
  2:1492: ScanMag2*1 ScanPhase2 + (37*ScanPhaseShiftA + 11*ScanPhaseShiftB)
  2:1493: ScanMag2*1 ScanPhase2 + (37*ScanPhaseShiftA + 12*ScanPhaseShiftB)
  2:1494: ScanMag2*1 ScanPhase2 + (37*ScanPhaseShiftA + 13*ScanPhaseShiftB)
  2:1495: ScanMag2*1 ScanPhase2 + (37*ScanPhaseShiftA + 14*ScanPhaseShiftB)
  2:1496: ScanMag2*1 ScanPhase2 + (37*ScanPhaseShiftA + 15*ScanPhaseShiftB)
  2:1497: ScanMag2*1 ScanPhase2 + (37*ScanPhaseShiftA + 16*ScanPhaseShiftB)
  2:1498: ScanMag2*1 ScanPhase2 + (37*ScanPhaseShiftA + 17*ScanPhaseShiftB)
  2:1499: ScanMag2*1 ScanPhase2 + (37*ScanPhaseShiftA + 18*ScanPhaseShiftB)
  2:1500: ScanMag2*1 ScanPhase2 + (37*ScanPhaseShiftA + 19*ScanPhaseShiftB)
  2:1501: ScanMag2*1 ScanPhase2 + (37*ScanPhaseShiftA + 20*ScanPhaseShiftB)
  2:1502: ScanMag2*1 ScanPhase2 + (37*ScanPhaseShiftA + 21*ScanPhaseShiftB)
  2:1503: ScanMag2*1 ScanPhase2 + (37*ScanPhaseShiftA + 22*ScanPhaseShiftB)
  2:1504: ScanMag2*1 ScanPhase2 + (37*ScanPhaseShiftA + 23*ScanPhaseShiftB)
  2:1505: ScanMag2*1 ScanPhase2 + (37*ScanPhaseShiftA + 24*ScanPhaseShiftB)
  2:1506: ScanMag2*1 ScanPhase2 + (37*ScanPhaseShiftA + 25*ScanPhaseShiftB)
  2:1507: ScanMag2*1 ScanPhase2 + (37*ScanPhaseShiftA + 26*ScanPhaseShiftB)
  2:1508: ScanMag2*1 ScanPhase2 + (37*ScanPhaseShiftA + 27*ScanPhaseShiftB)
  2:1509: ScanMag2*1 ScanPhase2 + (37*ScanPhaseShiftA + 28*ScanPhaseShiftB)
  2:1510: ScanMag2*1 ScanPhase2 + (37*ScanPhaseShiftA + 29*ScanPhaseShiftB)
  2:1511: ScanMag2*1 ScanPhase2 + (37*ScanPhaseShiftA + 30*ScanPhaseShiftB)
  2:1512: ScanMag2*1 ScanPhase2 + (37*ScanPhaseShiftA + 31*ScanPhaseShiftB)
  2:1513: ScanMag2*1 ScanPhase2 + (37*ScanPhaseShiftA + 32*ScanPhaseShiftB)
  2:1514: ScanMag2*1 ScanPhase2 + (37*ScanPhaseShiftA + 33*ScanPhaseShiftB)
  2:1515: ScanMag2*1 ScanPhase2 + (37*ScanPhaseShiftA + 34*ScanPhaseShiftB)
  2:1516: ScanMag2*1 ScanPhase2 + (37*ScanPhaseShiftA + 35*ScanPhaseShiftB)
  2:1517: ScanMag2*1 ScanPhase2 + (37*ScanPhaseShiftA + 36*ScanPhaseShiftB)
  2:1518: ScanMag2*1 ScanPhase2 + (37*ScanPhaseShiftA + 37*ScanPhaseShiftB)
  2:1519: ScanMag2*1 ScanPhase2 + (37*ScanPhaseShiftA + 38*ScanPhaseShiftB)
  2:1520: ScanMag2*1 ScanPhase2 + (37*ScanPhaseShiftA + 39*ScanPhaseShiftB)
  2:1521: ScanMag2*1 ScanPhase2 + (38*ScanPhaseShiftA + 0*ScanPhaseShiftB)
  2:1522: ScanMag2*1 ScanPhase2 + (38*ScanPhaseShiftA + 1*ScanPhaseShiftB)
  2:1523: ScanMag2*1 ScanPhase2 + (38*ScanPhaseShiftA + 2*ScanPhaseShiftB)
  2:1524: ScanMag2*1 ScanPhase2 + (38*ScanPhaseShiftA + 3*ScanPhaseShiftB)
  2:1525: ScanMag2*1 ScanPhase2 + (38*ScanPhaseShiftA + 4*ScanPhaseShiftB)
  2:1526: ScanMag2*1 ScanPhase2 + (38*ScanPhaseShiftA + 5*ScanPhaseShiftB)
  2:1527: ScanMag2*1 ScanPhase2 + (38*ScanPhaseShiftA + 6*ScanPhaseShiftB)
  2:1528: ScanMag2*1 ScanPhase2 + (38*ScanPhaseShiftA + 7*ScanPhaseShiftB)
  2:1529: ScanMag2*1 ScanPhase2 + (38*ScanPhaseShiftA + 8*ScanPhaseShiftB)
  2:1530: ScanMag2*1 ScanPhase2 + (38*ScanPhaseShiftA + 9*ScanPhaseShiftB)
  2:1531: ScanMag2*1 ScanPhase2 + (38*ScanPhaseShiftA + 10*ScanPhaseShiftB)
  2:1532: ScanMag2*1 ScanPhase2 + (38*ScanPhaseShiftA + 11*ScanPhaseShiftB)
  2:1533: ScanMag2*1 ScanPhase2 + (38*ScanPhaseShiftA + 12*ScanPhaseShiftB)
  2:1534: ScanMag2*1 ScanPhase2 + (38*ScanPhaseShiftA + 13*ScanPhaseShiftB)
  2:1535: ScanMag2*1 ScanPhase2 + (38*ScanPhaseShiftA + 14*ScanPhaseShiftB)
  2:1536: ScanMag2*1 ScanPhase2 + (38*ScanPhaseShiftA + 15*ScanPhaseShiftB)
  2:1537: ScanMag2*1 ScanPhase2 + (38*ScanPhaseShiftA + 16*ScanPhaseShiftB)
  2:1538: ScanMag2*1 ScanPhase2 + (38*ScanPhaseShiftA + 17*ScanPhaseShiftB)
  2:1539: ScanMag2*1 ScanPhase2 + (38*ScanPhaseShiftA + 18*ScanPhaseShiftB)
  2:1540: ScanMag2*1 ScanPhase2 + (38*ScanPhaseShiftA + 19*ScanPhaseShiftB)
  2:1541: ScanMag2*1 ScanPhase2 + (38*ScanPhaseShiftA + 20*ScanPhaseShiftB)
  2:1542: ScanMag2*1 ScanPhase2 + (38*ScanPhaseShiftA + 21*ScanPhaseShiftB)
  2:1543: ScanMag2*1 ScanPhase2 + (38*ScanPhaseShiftA + 22*ScanPhaseShiftB)
  2:1544: ScanMag2*1 ScanPhase2 + (38*ScanPhaseShiftA + 23*ScanPhaseShiftB)
  2:1545: ScanMag2*1 ScanPhase2 + (38*ScanPhaseShiftA + 24*ScanPhaseShiftB)
  2:1546: ScanMag2*1 ScanPhase2 + (38*ScanPhaseShiftA + 25*ScanPhaseShiftB)
  2:1547: ScanMag2*1 ScanPhase2 + (38*ScanPhaseShiftA + 26*ScanPhaseShiftB)
  2:1548: ScanMag2*1 ScanPhase2 + (38*ScanPhaseShiftA + 27*ScanPhaseShiftB)
  2:1549: ScanMag2*1 ScanPhase2 + (38*ScanPhaseShiftA + 28*ScanPhaseShiftB)
  2:1550: ScanMag2*1 ScanPhase2 + (38*ScanPhaseShiftA + 29*ScanPhaseShiftB)
  2:1551: ScanMag2*1 ScanPhase2 + (38*ScanPhaseShiftA + 30*ScanPhaseShiftB)
  2:1552: ScanMag2*1 ScanPhase2 + (38*ScanPhaseShiftA + 31*ScanPhaseShiftB)
  2:1553: ScanMag2*1 ScanPhase2 + (38*ScanPhaseShiftA + 32*ScanPhaseShiftB)
  2:1554: ScanMag2*1 ScanPhase2 + (38*ScanPhaseShiftA + 33*ScanPhaseShiftB)
  2:1555: ScanMag2*1 ScanPhase2 + (38*ScanPhaseShiftA + 34*ScanPhaseShiftB)
  2:1556: ScanMag2*1 ScanPhase2 + (38*ScanPhaseShiftA + 35*ScanPhaseShiftB)
  2:1557: ScanMag2*1 ScanPhase2 + (38*ScanPhaseShiftA + 36*ScanPhaseShiftB)
  2:1558: ScanMag2*1 ScanPhase2 + (38*ScanPhaseShiftA + 37*ScanPhaseShiftB)
  2:1559: ScanMag2*1 ScanPhase2 + (38*ScanPhaseShiftA + 38*ScanPhaseShiftB)
  2:1560: ScanMag2*1 ScanPhase2 + (38*ScanPhaseShiftA + 39*ScanPhaseShiftB)
  2:1561: ScanMag2*1 ScanPhase2 + (39*ScanPhaseShiftA + 0*ScanPhaseShiftB)
  2:1562: ScanMag2*1 ScanPhase2 + (39*ScanPhaseShiftA + 1*ScanPhaseShiftB)
  2:1563: ScanMag2*1 ScanPhase2 + (39*ScanPhaseShiftA + 2*ScanPhaseShiftB)
  2:1564: ScanMag2*1 ScanPhase2 + (39*ScanPhaseShiftA + 3*ScanPhaseShiftB)
  2:1565: ScanMag2*1 ScanPhase2 + (39*ScanPhaseShiftA + 4*ScanPhaseShiftB)
  2:1566: ScanMag2*1 ScanPhase2 + (39*ScanPhaseShiftA + 5*ScanPhaseShiftB)
  2:1567: ScanMag2*1 ScanPhase2 + (39*ScanPhaseShiftA + 6*ScanPhaseShiftB)
  2:1568: ScanMag2*1 ScanPhase2 + (39*ScanPhaseShiftA + 7*ScanPhaseShiftB)
  2:1569: ScanMag2*1 ScanPhase2 + (39*ScanPhaseShiftA + 8*ScanPhaseShiftB)
  2:1570: ScanMag2*1 ScanPhase2 + (39*ScanPhaseShiftA + 9*ScanPhaseShiftB)
  2:1571: ScanMag2*1 ScanPhase2 + (39*ScanPhaseShiftA + 10*ScanPhaseShiftB)
  2:1572: ScanMag2*1 ScanPhase2 + (39*ScanPhaseShiftA + 11*ScanPhaseShiftB)
  2:1573: ScanMag2*1 ScanPhase2 + (39*ScanPhaseShiftA + 12*ScanPhaseShiftB)
  2:1574: ScanMag2*1 ScanPhase2 + (39*ScanPhaseShiftA + 13*ScanPhaseShiftB)
  2:1575: ScanMag2*1 ScanPhase2 + (39*ScanPhaseShiftA + 14*ScanPhaseShiftB)
  2:1576: ScanMag2*1 ScanPhase2 + (39*ScanPhaseShiftA + 15*ScanPhaseShiftB)
  2:1577: ScanMag2*1 ScanPhase2 + (39*ScanPhaseShiftA + 16*ScanPhaseShiftB)
  2:1578: ScanMag2*1 ScanPhase2 + (39*ScanPhaseShiftA + 17*ScanPhaseShiftB)
  2:1579: ScanMag2*1 ScanPhase2 + (39*ScanPhaseShiftA + 18*ScanPhaseShiftB)
  2:1580: ScanMag2*1 ScanPhase2 + (39*ScanPhaseShiftA + 19*ScanPhaseShiftB)
  2:1581: ScanMag2*1 ScanPhase2 + (39*ScanPhaseShiftA + 20*ScanPhaseShiftB)
  2:1582: ScanMag2*1 ScanPhase2 + (39*ScanPhaseShiftA + 21*ScanPhaseShiftB)
  2:1583: ScanMag2*1 ScanPhase2 + (39*ScanPhaseShiftA + 22*ScanPhaseShiftB)
  2:1584: ScanMag2*1 ScanPhase2 + (39*ScanPhaseShiftA + 23*ScanPhaseShiftB)
  2:1585: ScanMag2*1 ScanPhase2 + (39*ScanPhaseShiftA + 24*ScanPhaseShiftB)
  2:1586: ScanMag2*1 ScanPhase2 + (39*ScanPhaseShiftA + 25*ScanPhaseShiftB)
  2:1587: ScanMag2*1 ScanPhase2 + (39*ScanPhaseShiftA + 26*ScanPhaseShiftB)
  2:1588: ScanMag2*1 ScanPhase2 + (39*ScanPhaseShiftA + 27*ScanPhaseShiftB)
  2:1589: ScanMag2*1 ScanPhase2 + (39*ScanPhaseShiftA + 28*ScanPhaseShiftB)
  2:1590: ScanMag2*1 ScanPhase2 + (39*ScanPhaseShiftA + 29*ScanPhaseShiftB)
  2:1591: ScanMag2*1 ScanPhase2 + (39*ScanPhaseShiftA + 30*ScanPhaseShiftB)
  2:1592: ScanMag2*1 ScanPhase2 + (39*ScanPhaseShiftA + 31*ScanPhaseShiftB)
  2:1593: ScanMag2*1 ScanPhase2 + (39*ScanPhaseShiftA + 32*ScanPhaseShiftB)
  2:1594: ScanMag2*1 ScanPhase2 + (39*ScanPhaseShiftA + 33*ScanPhaseShiftB)
  2:1595: ScanMag2*1 ScanPhase2 + (39*ScanPhaseShiftA + 34*ScanPhaseShiftB)
  2:1596: ScanMag2*1 ScanPhase2 + (39*ScanPhaseShiftA + 35*ScanPhaseShiftB)
  2:1597: ScanMag2*1 ScanPhase2 + (39*ScanPhaseShiftA + 36*ScanPhaseShiftB)
  2:1598: ScanMag2*1 ScanPhase2 + (39*ScanPhaseShiftA + 37*ScanPhaseShiftB)
  2:1599: ScanMag2*1 ScanPhase2 + (39*ScanPhaseShiftA + 38*ScanPhaseShiftB)
  2:1600: ScanMag2*1 ScanPhase2 + (39*ScanPhaseShiftA + 39*ScanPhaseShiftB)
radiation setups:
  3D: Infinite Sphere Theta=0deg..180deg step 2deg Phi=-180deg..180deg step 2deg
  Azimuth: Infinite Sphere Theta=90deg..90deg step 0deg Phi=-180deg..180deg step 1deg
  Elevation: Infinite Sphere Theta=-180deg..180deg step 1deg Phi=90deg..90deg step 0deg
  Infinite Sphere_3D: Infinite Sphere Theta=0deg..180deg step 2deg Phi=0deg..360deg step 2deg
reports:
  Gain Plot 1: dB(GainTotal) vs Phi, Theta on Setup1 : LastAdaptive, 3D [Freq=4.5GHz]

design my_HFSSDesign_40_40 (HFSS, DrivenModal, model units mm)
variables:
  Phi_Scan = 0deg
  Theta_Scan = 0deg
  ScanFrequency = 4500000000Hz
  ScanAngleTheta = 90deg
  ScanAnglePhi = 0deg
  ScanPhaseShiftA = -((ScanFrequency*0.0*sin(ScanAngleTheta)*cos(ScanAnglePhi)) + (ScanFrequency*7.12587307464e-10*sin(ScanAngleTheta)*sin(ScanAnglePhi))) rad
  ScanPhaseShiftB = -((ScanFrequency*7.54504207903e-10*sin(ScanAngleTheta)*cos(ScanAnglePhi)) + (ScanFrequency*0.0*sin(ScanAngleTheta)*sin(ScanAnglePhi))) rad
  ScanMag1 = 1W
  ScanPhase1 = 0deg
  ScanMag2 = 1W
  ScanPhase2 = 0deg
geometry:
  inner = imported_body(C:\Users\zhang\Documents\Ansoft\vivaldi_test\Vivaldi_Script_export\VivaldiUnitCell.step)
  outer [tongzhouxian_epoxy1] = imported_body(C:\Users\zhang\Documents\Ansoft\vivaldi_test\Vivaldi_Script_export\VivaldiUnitCell.step)
  substrate [Rogers TMM 6 (tm)] = imported_body(C:\Users\zhang\Documents\Ansoft\vivaldi_test\Vivaldi_Script_export\VivaldiUnitCell.step)
  airbox [air] = imported_body(C:\Users\zhang\Documents\Ansoft\vivaldi_test\Vivaldi_Script_export\VivaldiUnitCell.step)
  EquationCurve1_1, EquationCurve1 = imported_body(C:\Users\zhang\Documents\Ansoft\vivaldi_test\Vivaldi_Script_export\VivaldiUnitCell.step)
  outer.subtract(inner)
  group VivaldiUnitCell = outer, substrate, airbox, EquationCurve1_1, EquationCurve1
boundaries and excitations:
  PerfE1: Perfect E Objects=[EquationCurve1, EquationCurve1_1]
  PerfE2: Perfect E Faces=?.face(#23, #24)
  PerfE3: Perfect E Faces=outer.face(at (-342, -662.75, -4), at (-342, -662, -4))
  LatticePair1: Lattice Pair Faces=?.face(#69, #71) CoordSysVector{(-360, -680, 60) -> (-360, -680, 0)} ReverseV PhaseDelay=UseScanAngle Phi=Phi_Scan Theta=Theta_Scan
  LatticePair2: Lattice Pair Faces=?.face(#70, #72) CoordSysVector{(-360, -646, 60) -> (-360, -646, 0)} ReverseV PhaseDelay=UseScanAngle Phi=Phi_Scan Theta=Theta_Scan
  Rad1: Radiation Faces=?.face(#67)
  1: Lumped Port Faces=?.face(#25) Modes{Mode1{IntLine{(-341.125, -662.375, -8) -> (-341.625, -662.375, -8)} CharImp=Zpi RenormImp=50ohm}} Impedance=50ohm
  2: Lumped Port Faces=?.face(#26) Modes{Mode1{IntLine{(-341.125, -662.375, 0) -> (-341.625, -662.375, 0)} CharImp=Zpi RenormImp=50ohm}} Impedance=50ohm
array:
  Type=Regular Name=Vivaldi_40_40 UseAirObjects RowPrimaryBnd=LatticePair1 ColumnPrimaryBnd=LatticePair2 RowDimension=40 ColumnDimension=40 RenderType=0 Padding=1 PostProcessRow=1 PostProcessCol=1
setups:
  Setup1: HfssDriven Frequency=4.5GHz MaxDeltaS=0.02 MaximumPasses=10 MinimumPasses=1 MinimumConvergedPasses=1 PercentRefinement=30 BasisOrder=1 PortAccuracy=2 DrivenSolverType="Direct Solver"
    sweep Sweep: 0.5GHz to 10GHz, 401 points; Type=Interpolating InterpTolerance=0.5 InterpMaxSolns=250 InterpUsePortImped=false PassivityErrorTolerance=0.0001
source amplitudes:
  1:1, 1:41, 1:81, 1:121, 1:161, 1:201, 1:241, 1:281, 1:321, 1:361, 1:401, 1:441, 1:481, 1:521, 1:561, 1:601, 1:641, 1:681, 1:721, 1:761, 1:801, 1:841, 1:881, 1:921, 1:961, 1:1001, 1:1041, 1:1081, 1:1121, 1:1161, 1:1201, 1:1241, 1:1281, 1:1321, 1:1361, 1:1401, 1:1441, 1:1481, 1:1521, 1:1561, 2:1, 2:41, 2:81, 2:121, 2:161, 2:201, 2:241, 2:281, 2:321, 2:361, 2:401, 2:441, 2:481, 2:521, 2:561, 2:601, 2:641, 2:681, 2:721, 2:761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: 1V -0deg
  1:2, 1:42, 1:82, 1:122, 1:162, 1:202, 1:242, 1:282, 1:322, 1:362, 1:402, 1:442, 1:482, 1:522, 1:562, 1:602, 1:642, 1:682, 1:722, 1:762, 1:802, 1:842, 1:882, 1:922, 1:962, 1:1002, 1:1042, 1:1082, 1:1122, 1:1162, 1:1202, 1:1242, 1:1282, 1:1322, 1:1362, 1:1402, 1:1442, 1:1482, 1:1522, 1:1562, 2:2, 2:42, 2:82, 2:122, 2:162, 2:202, 2:242, 2:282, 2:322, 2:362, 2:402, 2:442, 2:482, 2:522, 2:562, 2:602, 2:642, 2:682, 2:722, 2:762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: 1V -194.53458032deg
  1:3, 1:43, 1:83, 1:123, 1:163, 1:203, 1:243, 1:283, 1:323, 1:363, 1:403, 1:443, 1:483, 1:523, 1:563, 1:603, 1:643, 1:683, 1:723, 1:763, 1:803, 1:843, 1:883, 1:923, 1:963, 1:1003, 1:1043, 1:1083, 1:1123, 1:1163, 1:1203, 1:1243, 1:1283, 1:1323, 1:1363, 1:1403, 1:1443, 1:1483, 1:1523, 1:1563, 2:3, 2:43, 2:83, 2:123, 2:163, 2:203, 2:243, 2:283, 2:323, 2:363, 2:403, 2:443, 2:483, 2:523, 2:563, 2:603, 2:643, 2:683, 2:723, 2:763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: 1V -389.069160639deg
  1:4, 1:44, 1:84, 1:124, 1:164, 1:204, 1:244, 1:284, 1:324, 1:364, 1:404, 1:444, 1:484, 1:524, 1:564, 1:604, 1:644, 1:684, 1:724, 1:764, 1:804, 1:844, 1:884, 1:924, 1:964, 1:1004, 1:1044, 1:1084, 1:1124, 1:1164, 1:1204, 1:1244, 1:1284, 1:1324, 1:1364, 1:1404, 1:1444, 1:1484, 1:1524, 1:1564, 2:4, 2:44, 2:84, 2:124, 2:164, 2:204, 2:244, 2:284, 2:324, 2:364, 2:404, 2:444, 2:484, 2:524, 2:564, 2:604, 2:644, 2:684, 2:724, 2:764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: 1V -583.603740959deg
  1:5, 1:45, 1:85, 1:125, 1:165, 1:205, 1:245, 1:285, 1:325, 1:365, 1:405, 1:445, 1:485, 1:525, 1:565, 1:605, 1:645, 1:685, 1:725, 1:765, 1:805, 1:845, 1:885, 1:925, 1:965, 1:1005, 1:1045, 1:1085, 1:1125, 1:1165, 1:1205, 1:1245, 1:1285, 1:1325, 1:1365, 1:1405, 1:1445, 1:1485, 1:1525, 1:1565, 2:5, 2:45, 2:85, 2:125, 2:165, 2:205, 2:245, 2:285, 2:325, 2:365, 2:405, 2:445, 2:485, 2:525, 2:565, 2:605, 2:645, 2:685, 2:725, 2:765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: 1V -778.138321278deg
  1:6, 1:46, 1:86, 1:126, 1:166, 1:206, 1:246, 1:286, 1:326, 1:366, 1:406, 1:446, 1:486, 1:526, 1:566, 1:606, 1:646, 1:686, 1:726, 1:766, 1:806, 1:846, 1:886, 1:926, 1:966, 1:1006, 1:1046, 1:1086, 1:1126, 1:1166, 1:1206, 1:1246, 1:1286, 1:1326, 1:1366, 1:1406, 1:1446, 1:1486, 1:1526, 1:1566, 2:6, 2:46, 2:86, 2:126, 2:166, 2:206, 2:246, 2:286, 2:326, 2:366, 2:406, 2:446, 2:486, 2:526, 2:566, 2:606, 2:646, 2:686, 2:726, 2:766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: 1V -972.672901598deg
  1:7, 1:47, 1:87, 1:127, 1:167, 1:207, 1:247, 1:287, 1:327, 1:367, 1:407, 1:447, 1:487, 1:527, 1:567, 1:607, 1:647, 1:687, 1:727, 1:767, 1:807, 1:847, 1:887, 1:927, 1:967, 1:1007, 1:1047, 1:1087, 1:1127, 1:1167, 1:1207, 1:1247, 1:1287, 1:1327, 1:1367, 1:1407, 1:1447, 1:1487, 1:1527, 1:1567, 2:7, 2:47, 2:87, 2:127, 2:167, 2:207, 2:247, 2:287, 2:327, 2:367, 2:407, 2:447, 2:487, 2:527, 2:567, 2:607, 2:647, 2:687, 2:727, 2:767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: 1V -1167.20748192deg
  1:8, 1:48, 1:88, 1:128, 1:168, 1:208, 1:248, 1:288, 1:328, 1:368, 1:408, 1:448, 1:488, 1:528, 1:568, 1:608, 1:648, 1:688, 1:728, 1:768, 1:808, 1:848, 1:888, 1:928, 1:968, 1:1008, 1:1048, 1:1088, 1:1128, 1:1168, 1:1208, 1:1248, 1:1288, 1:1328, 1:1368, 1:1408, 1:1448, 1:1488, 1:1528, 1:1568, 2:8, 2:48, 2:88, 2:128, 2:168, 2:208, 2:248, 2:288, 2:328, 2:368, 2:408, 2:448, 2:488, 2:528, 2:568, 2:608, 2:648, 2:688, 2:728, 2:768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: 1V -1361.74206224deg
  1:9, 1:49, 1:89, 1:129, 1:169, 1:209, 1:249, 1:289, 1:329, 1:369, 1:409, 1:449, 1:489, 1:529, 1:569, 1:609, 1:649, 1:689, 1:729, 1:769, 1:809, 1:849, 1:889, 1:929, 1:969, 1:1009, 1:1049, 1:1089, 1:1129, 1:1169, 1:1209, 1:1249, 1:1289, 1:1329, 1:1369, 1:1409, 1:1449, 1:1489, 1:1529, 1:1569, 2:9, 2:49, 2:89, 2:129, 2:169, 2:209, 2:249, 2:289, 2:329, 2:369, 2:409, 2:449, 2:489, 2:529, 2:569, 2:609, 2:649, 2:689, 2:729, 2:769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: 1V -1556.27664256deg
  1:10, 1:50, 1:90, 1:130, 1:170, 1:210, 1:250, 1:290, 1:330, 1:370, 1:410, 1:450, 1:490, 1:530, 1:570, 1:610, 1:650, 1:690, 1:730, 1:770, 1:810, 1:850, 1:890, 1:930, 1:970, 1:1010, 1:1050, 1:1090, 1:1130, 1:1170, 1:1210, 1:1250, 1:1290, 1:1330, 1:1370, 1:1410, 1:1450, 1:1490, 1:1530, 1:1570, 2:10, 2:50, 2:90, 2:130, 2:170, 2:210, 2:250, 2:290, 2:330, 2:370, 2:410, 2:450, 2:490, 2:530, 2:570, 2:610, 2:650, 2:690, 2:730, 2:770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: 1V -1750.81122288deg
  1:11, 1:51, 1:91, 1:131, 1:171, 1:211, 1:251, 1:291, 1:331, 1:371, 1:411, 1:451, 1:491, 1:531, 1:571, 1:611, 1:651, 1:691, 1:731, 1:771, 1:811, 1:851, 1:891, 1:931, 1:971, 1:1011, 1:1051, 1:1091, 1:1131, 1:1171, 1:1211, 1:1251, 1:1291, 1:1331, 1:1371, 1:1411, 1:1451, 1:1491, 1:1531, 1:1571, 2:11, 2:51, 2:91, 2:131, 2:171, 2:211, 2:251, 2:291, 2:331, 2:371, 2:411, 2:451, 2:491, 2:531, 2:571, 2:611, 2:651, 2:691, 2:731, 2:771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: 1V -1945.3458032deg
  1:12, 1:52, 1:92, 1:132, 1:172, 1:212, 1:252, 1:292, 1:332, 1:372, 1:412, 1:452, 1:492, 1:532, 1:572, 1:612, 1:652, 1:692, 1:732, 1:772, 1:812, 1:852, 1:892, 1:932, 1:972, 1:1012, 1:1052, 1:1092, 1:1132, 1:1172, 1:1212, 1:1252, 1:1292, 1:1332, 1:1372, 1:1412, 1:1452, 1:1492, 1:1532, 1:1572, 2:12, 2:52, 2:92, 2:132, 2:172, 2:212, 2:252, 2:292, 2:332, 2:372, 2:412, 2:452, 2:492, 2:532, 2:572, 2:612, 2:652, 2:692, 2:732, 2:772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: 1V -2139.88038352deg
  1:13, 1:53, 1:93, 1:133, 1:173, 1:213, 1:253, 1:293, 1:333, 1:373, 1:413, 1:453, 1:493, 1:533, 1:573, 1:613, 1:653, 1:693, 1:733, 1:773, 1:813, 1:853, 1:893, 1:933, 1:973, 1:1013, 1:1053, 1:1093, 1:1133, 1:1173, 1:1213, 1:1253, 1:1293, 1:1333, 1:1373, 1:1413, 1:1453, 1:1493, 1:1533, 1:1573, 2:13, 2:53, 2:93, 2:133, 2:173, 2:213, 2:253, 2:293, 2:333, 2:373, 2:413, 2:453, 2:493, 2:533, 2:573, 2:613, 2:653, 2:693, 2:733, 2:773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: 1V -2334.41496383deg
  1:14, 1:54, 1:94, 1:134, 1:174, 1:214, 1:254, 1:294, 1:334, 1:374, 1:414, 1:454, 1:494, 1:534, 1:574, 1:614, 1:654, 1:694, 1:734, 1:774, 1:814, 1:854, 1:894, 1:934, 1:974, 1:1014, 1:1054, 1:1094, 1:1134, 1:1174, 1:1214, 1:1254, 1:1294, 1:1334, 1:1374, 1:1414, 1:1454, 1:1494, 1:1534, 1:1574, 2:14, 2:54, 2:94, 2:134, 2:174, 2:214, 2:254, 2:294, 2:334, 2:374, 2:414, 2:454, 2:494, 2:534, 2:574, 2:614, 2:654, 2:694, 2:734, 2:774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: 1V -2528.94954415deg
  1:15, 1:55, 1:95, 1:135, 1:175, 1:215, 1:255, 1:295, 1:335, 1:375, 1:415, 1:455, 1:495, 1:535, 1:575, 1:615, 1:655, 1:695, 1:735, 1:775, 1:815, 1:855, 1:895, 1:935, 1:975, 1:1015, 1:1055, 1:1095, 1:1135, 1:1175, 1:1215, 1:1255, 1:1295, 1:1335, 1:1375, 1:1415, 1:1455, 1:1495, 1:1535, 1:1575, 2:15, 2:55, 2:95, 2:135, 2:175, 2:215, 2:255, 2:295, 2:335, 2:375, 2:415, 2:455, 2:495, 2:535, 2:575, 2:615, 2:655, 2:695, 2:735, 2:775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: 1V -2723.48412447deg
  1:16, 1:56, 1:96, 1:136, 1:176, 1:216, 1:256, 1:296, 1:336, 1:376, 1:416, 1:456, 1:496, 1:536, 1:576, 1:616, 1:656, 1:696, 1:736, 1:776, 1:816, 1:856, 1:896, 1:936, 1:976, 1:1016, 1:1056, 1:1096, 1:1136, 1:1176, 1:1216, 1:1256, 1:1296, 1:1336, 1:1376, 1:1416, 1:1456, 1:1496, 1:1536, 1:1576, 2:16, 2:56, 2:96, 2:136, 2:176, 2:216, 2:256, 2:296, 2:336, 2:376, 2:416, 2:456, 2:496, 2:536, 2:576, 2:616, 2:656, 2:696, 2:736, 2:776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: 1V -2918.01870479deg
  1:17, 1:57, 1:97, 1:137, 1:177, 1:217, 1:257, 1:297, 1:337, 1:377, 1:417, 1:457, 1:497, 1:537, 1:577, 1:617, 1:657, 1:697, 1:737, 1:777, 1:817, 1:857, 1:897, 1:937, 1:977, 1:1017, 1:1057, 1:1097, 1:1137, 1:1177, 1:1217, 1:1257, 1:1297, 1:1337, 1:1377, 1:1417, 1:1457, 1:1497, 1:1537, 1:1577, 2:17, 2:57, 2:97, 2:137, 2:177, 2:217, 2:257, 2:297, 2:337, 2:377, 2:417, 2:457, 2:497, 2:537, 2:577, 2:617, 2:657, 2:697, 2:737, 2:777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: 1V -3112.55328511deg
  1:18, 1:58, 1:98, 1:138, 1:178, 1:218, 1:258, 1:298, 1:338, 1:378, 1:418, 1:458, 1:498, 1:538, 1:578, 1:618, 1:658, 1:698, 1:738, 1:778, 1:818, 1:858, 1:898, 1:938, 1:978, 1:1018, 1:1058, 1:1098, 1:1138, 1:1178, 1:1218, 1:1258, 1:1298, 1:1338, 1:1378, 1:1418, 1:1458, 1:1498, 1:1538, 1:1578, 2:18, 2:58, 2:98, 2:138, 2:178, 2:218, 2:258, 2:298, 2:338, 2:378, 2:418, 2:458, 2:498, 2:538, 2:578, 2:618, 2:658, 2:698, 2:738, 2:778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: 1V -3307.08786543deg
  1:19, 1:59, 1:99, 1:139, 1:179, 1:219, 1:259, 1:299, 1:339, 1:379, 1:419, 1:459, 1:499, 1:539, 1:579, 1:619, 1:659, 1:699, 1:739, 1:779, 1:819, 1:859, 1:899, 1:939, 1:979, 1:1019, 1:1059, 1:1099, 1:1139, 1:1179, 1:1219, 1:1259, 1:1299, 1:1339, 1:1379, 1:1419, 1:1459, 1:1499, 1:1539, 1:1579, 2:19, 2:59, 2:99, 2:139, 2:179, 2:219, 2:259, 2:299, 2:339, 2:379, 2:419, 2:459, 2:499, 2:539, 2:579, 2:619, 2:659, 2:699, 2:739, 2:779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: 1V -3501.62244575deg
  1:20, 1:60, 1:100, 1:140, 1:180, 1:220, 1:260, 1:300, 1:340, 1:380, 1:420, 1:460, 1:500, 1:540, 1:580, 1:620, 1:660, 1:700, 1:740, 1:780, 1:820, 1:860, 1:900, 1:940, 1:980, 1:1020, 1:1060, 1:1100, 1:1140, 1:1180, 1:1220, 1:1260, 1:1300, 1:1340, 1:1380, 1:1420, 1:1460, 1:1500, 1:1540, 1:1580, 2:20, 2:60, 2:100, 2:140, 2:180, 2:220, 2:260, 2:300, 2:340, 2:380, 2:420, 2:460, 2:500, 2:540, 2:580, 2:620, 2:660, 2:700, 2:740, 2:780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: 1V -3696.15702607deg
  1:21, 1:61, 1:101, 1:141, 1:181, 1:221, 1:261, 1:301, 1:341, 1:381, 1:421, 1:461, 1:501, 1:541, 1:581, 1:621, 1:661, 1:701, 1:741, 1:781, 1:821, 1:861, 1:901, 1:941, 1:981, 1:1021, 1:1061, 1:1101, 1:1141, 1:1181, 1:1221, 1:1261, 1:1301, 1:1341, 1:1381, 1:1421, 1:1461, 1:1501, 1:1541, 1:1581, 2:21, 2:61, 2:101, 2:141, 2:181, 2:221, 2:261, 2:301, 2:341, 2:381, 2:421, 2:461, 2:501, 2:541, 2:581, 2:621, 2:661, 2:701, 2:741, 2:781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: 1V -3890.69160639deg
  1:22, 1:62, 1:102, 1:142, 1:182, 1:222, 1:262, 1:302, 1:342, 1:382, 1:422, 1:462, 1:502, 1:542, 1:582, 1:622, 1:662, 1:702, 1:742, 1:782, 1:822, 1:862, 1:902, 1:942, 1:982, 1:1022, 1:1062, 1:1102, 1:1142, 1:1182, 1:1222, 1:1262, 1:1302, 1:1342, 1:1382, 1:1422, 1:1462, 1:1502, 1:1542, 1:1582, 2:22, 2:62, 2:102, 2:142, 2:182, 2:222, 2:262, 2:302, 2:342, 2:382, 2:422, 2:462, 2:502, 2:542, 2:582, 2:622, 2:662, 2:702, 2:742, 2:782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: 1V -4085.22618671deg
  1:23, 1:63, 1:103, 1:143, 1:183, 1:223, 1:263, 1:303, 1:343, 1:383, 1:423, 1:463, 1:503, 1:543, 1:583, 1:623, 1:663, 1:703, 1:743, 1:783, 1:823, 1:863, 1:903, 1:943, 1:983, 1:1023, 1:1063, 1:1103, 1:1143, 1:1183, 1:1223, 1:1263, 1:1303, 1:1343, 1:1383, 1:1423, 1:1463, 1:1503, 1:1543, 1:1583, 2:23, 2:63, 2:103, 2:143, 2:183, 2:223, 2:263, 2:303, 2:343, 2:383, 2:423, 2:463, 2:503, 2:543, 2:583, 2:623, 2:663, 2:703, 2:743, 2:783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: 1V -4279.76076703deg
  1:24, 1:64, 1:104, 1:144, 1:184, 1:224, 1:264, 1:304, 1:344, 1:384, 1:424, 1:464, 1:504, 1:544, 1:584, 1:624, 1:664, 1:704, 1:744, 1:784, 1:824, 1:864, 1:904, 1:944, 1:984, 1:1024, 1:1064, 1:1104, 1:1144, 1:1184, 1:1224, 1:1264, 1:1304, 1:1344, 1:1384, 1:1424, 1:1464, 1:1504, 1:1544, 1:1584, 2:24, 2:64, 2:104, 2:144, 2:184, 2:224, 2:264, 2:304, 2:344, 2:384, 2:424, 2:464, 2:504, 2:544, 2:584, 2:624, 2:664, 2:704, 2:744, 2:784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: 1V -4474.29534735deg
  1:25, 1:65, 1:105, 1:145, 1:185, 1:225, 1:265, 1:305, 1:345, 1:385, 1:425, 1:465, 1:505, 1:545, 1:585, 1:625, 1:665, 1:705, 1:745, 1:785, 1:825, 1:865, 1:905, 1:945, 1:985, 1:1025, 1:1065, 1:1105, 1:1145, 1:1185, 1:1225, 1:1265, 1:1305, 1:1345, 1:1385, 1:1425, 1:1465, 1:1505, 1:1545, 1:1585, 2:25, 2:65, 2:105, 2:145, 2:185, 2:225, 2:265, 2:305, 2:345, 2:385, 2:425, 2:465, 2:505, 2:545, 2:585, 2:625, 2:665, 2:705, 2:745, 2:785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: 1V -4668.82992767deg
  1:26, 1:66, 1:106, 1:146, 1:186, 1:226, 1:266, 1:306, 1:346, 1:386, 1:426, 1:466, 1:506, 1:546, 1:586, 1:626, 1:666, 1:706, 1:746, 1:786, 1:826, 1:866, 1:906, 1:946, 1:986, 1:1026, 1:1066, 1:1106, 1:1146, 1:1186, 1:1226, 1:1266, 1:1306, 1:1346, 1:1386, 1:1426, 1:1466, 1:1506, 1:1546, 1:1586, 2:26, 2:66, 2:106, 2:146, 2:186, 2:226, 2:266, 2:306, 2:346, 2:386, 2:426, 2:466, 2:506, 2:546, 2:586, 2:626, 2:666, 2:706, 2:746, 2:786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: 1V -4863.36450799deg
  1:27, 1:67, 1:107, 1:147, 1:187, 1:227, 1:267, 1:307, 1:347, 1:387, 1:427, 1:467, 1:507, 1:547, 1:587, 1:627, 1:667, 1:707, 1:747, 1:787, 1:827, 1:867, 1:907, 1:947, 1:987, 1:1027, 1:1067, 1:1107, 1:1147, 1:1187, 1:1227, 1:1267, 1:1307, 1:1347, 1:1387, 1:1427, 1:1467, 1:1507, 1:1547, 1:1587, 2:27, 2:67, 2:107, 2:147, 2:187, 2:227, 2:267, 2:307, 2:347, 2:387, 2:427, 2:467, 2:507, 2:547, 2:587, 2:627, 2:667, 2:707, 2:747, 2:787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: 1V -5057.89908831deg
  1:28, 1:68, 1:108, 1:148, 1:188, 1:228, 1:268, 1:308, 1:348, 1:388, 1:428, 1:468, 1:508, 1:548, 1:588, 1:628, 1:668, 1:708, 1:748, 1:788, 1:828, 1:868, 1:908, 1:948, 1:988, 1:1028, 1:1068, 1:1108, 1:1148, 1:1188, 1:1228, 1:1268, 1:1308, 1:1348, 1:1388, 1:1428, 1:1468, 1:1508, 1:1548, 1:1588, 2:28, 2:68, 2:108, 2:148, 2:188, 2:228, 2:268, 2:308, 2:348, 2:388, 2:428, 2:468, 2:508, 2:548, 2:588, 2:628, 2:668, 2:708, 2:748, 2:788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: 1V -5252.43366863deg
  1:29, 1:69, 1:109, 1:149, 1:189, 1:229, 1:269, 1:309, 1:349, 1:389, 1:429, 1:469, 1:509, 1:549, 1:589, 1:629, 1:669, 1:709, 1:749, 1:789, 1:829, 1:869, 1:909, 1:949, 1:989, 1:1029, 1:1069, 1:1109, 1:1149, 1:1189, 1:1229, 1:1269, 1:1309, 1:1349, 1:1389, 1:1429, 1:1469, 1:1509, 1:1549, 1:1589, 2:29, 2:69, 2:109, 2:149, 2:189, 2:229, 2:269, 2:309, 2:349, 2:389, 2:429, 2:469, 2:509, 2:549, 2:589, 2:629, 2:669, 2:709, 2:749, 2:789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: 1V -5446.96824895deg
  1:30, 1:70, 1:110, 1:150, 1:190, 1:230, 1:270, 1:310, 1:350, 1:390, 1:430, 1:470, 1:510, 1:550, 1:590, 1:630, 1:670, 1:710, 1:750, 1:790, 1:830, 1:870, 1:910, 1:950, 1:990, 1:1030, 1:1070, 1:1110, 1:1150, 1:1190, 1:1230, 1:1270, 1:1310, 1:1350, 1:1390, 1:1430, 1:1470, 1:1510, 1:1550, 1:1590, 2:30, 2:70, 2:110, 2:150, 2:190, 2:230, 2:270, 2:310, 2:350, 2:390, 2:430, 2:470, 2:510, 2:550, 2:590, 2:630, 2:670, 2:710, 2:750, 2:790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: 1V -5641.50282927deg
  1:31, 1:71, 1:111, 1:151, 1:191, 1:231, 1:271, 1:311, 1:351, 1:391, 1:431, 1:471, 1:511, 1:551, 1:591, 1:631, 1:671, 1:711, 1:751, 1:791, 1:831, 1:871, 1:911, 1:951, 1:991, 1:1031, 1:1071, 1:1111, 1:1151, 1:1191, 1:1231, 1:1271, 1:1311, 1:1351, 1:1391, 1:1431, 1:1471, 1:1511, 1:1551, 1:1591, 2:31, 2:71, 2:111, 2:151, 2:191, 2:231, 2:271, 2:311, 2:351, 2:391, 2:431, 2:471, 2:511, 2:551, 2:591, 2:631, 2:671, 2:711, 2:751, 2:791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: 1V -5836.03740959deg
  1:32, 1:72, 1:112, 1:152, 1:192, 1:232, 1:272, 1:312, 1:352, 1:392, 1:432, 1:472, 1:512, 1:552, 1:592, 1:632, 1:672, 1:712, 1:752, 1:792, 1:832, 1:872, 1:912, 1:952, 1:992, 1:1032, 1:1072, 1:1112, 1:1152, 1:1192, 1:1232, 1:1272, 1:1312, 1:1352, 1:1392, 1:1432, 1:1472, 1:1512, 1:1552, 1:1592, 2:32, 2:72, 2:112, 2:152, 2:192, 2:232, 2:272, 2:312, 2:352, 2:392, 2:432, 2:472, 2:512, 2:552, 2:592, 2:632, 2:672, 2:712, 2:752, 2:792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: 1V -6030.57198991deg
  1:33, 1:73, 1:113, 1:153, 1:193, 1:233, 1:273, 1:313, 1:353, 1:393, 1:433, 1:473, 1:513, 1:553, 1:593, 1:633, 1:673, 1:713, 1:753, 1:793, 1:833, 1:873, 1:913, 1:953, 1:993, 1:1033, 1:1073, 1:1113, 1:1153, 1:1193, 1:1233, 1:1273, 1:1313, 1:1353, 1:1393, 1:1433, 1:1473, 1:1513, 1:1553, 1:1593, 2:33, 2:73, 2:113, 2:153, 2:193, 2:233, 2:273, 2:313, 2:353, 2:393, 2:433, 2:473, 2:513, 2:553, 2:593, 2:633, 2:673, 2:713, 2:753, 2:793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: 1V -6225.10657023deg
  1:34, 1:74, 1:114, 1:154, 1:194, 1:234, 1:274, 1:314, 1:354, 1:394, 1:434, 1:474, 1:514, 1:554, 1:594, 1:634, 1:674, 1:714, 1:754, 1:794, 1:834, 1:874, 1:914, 1:954, 1:994, 1:1034, 1:1074, 1:1114, 1:1154, 1:1194, 1:1234, 1:1274, 1:1314, 1:1354, 1:1394, 1:1434, 1:1474, 1:1514, 1:1554, 1:1594, 2:34, 2:74, 2:114, 2:154, 2:194, 2:234, 2:274, 2:314, 2:354, 2:394, 2:434, 2:474, 2:514, 2:554, 2:594, 2:634, 2:674, 2:714, 2:754, 2:794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: 1V -6419.64115055deg
  1:35, 1:75, 1:115, 1:155, 1:195, 1:235, 1:275, 1:315, 1:355, 1:395, 1:435, 1:475, 1:515, 1:555, 1:595, 1:635, 1:675, 1:715, 1:755, 1:795, 1:835, 1:875, 1:915, 1:955, 1:995, 1:1035, 1:1075, 1:1115, 1:1155, 1:1195, 1:1235, 1:1275, 1:1315, 1:1355, 1:1395, 1:1435, 1:1475, 1:1515, 1:1555, 1:1595, 2:35, 2:75, 2:115, 2:155, 2:195, 2:235, 2:275, 2:315, 2:355, 2:395, 2:435, 2:475, 2:515, 2:555, 2:595, 2:635, 2:675, 2:715, 2:755, 2:795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: 1V -6614.17573087deg
  1:36, 1:76, 1:116, 1:156, 1:196, 1:236, 1:276, 1:316, 1:356, 1:396, 1:436, 1:476, 1:516, 1:556, 1:596, 1:636, 1:676, 1:716, 1:756, 1:796, 1:836, 1:876, 1:916, 1:956, 1:996, 1:1036, 1:1076, 1:1116, 1:1156, 1:1196, 1:1236, 1:1276, 1:1316, 1:1356, 1:1396, 1:1436, 1:1476, 1:1516, 1:1556, 1:1596, 2:36, 2:76, 2:116, 2:156, 2:196, 2:236, 2:276, 2:316, 2:356, 2:396, 2:436, 2:476, 2:516, 2:556, 2:596, 2:636, 2:676, 2:716, 2:756, 2:796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: 1V -6808.71031118deg
  1:37, 1:77, 1:117, 1:157, 1:197, 1:237, 1:277, 1:317, 1:357, 1:397, 1:437, 1:477, 1:517, 1:557, 1:597, 1:637, 1:677, 1:717, 1:757, 1:797, 1:837, 1:877, 1:917, 1:957, 1:997, 1:1037, 1:1077, 1:1117, 1:1157, 1:1197, 1:1237, 1:1277, 1:1317, 1:1357, 1:1397, 1:1437, 1:1477, 1:1517, 1:1557, 1:1597, 2:37, 2:77, 2:117, 2:157, 2:197, 2:237, 2:277, 2:317, 2:357, 2:397, 2:437, 2:477, 2:517, 2:557, 2:597, 2:637, 2:677, 2:717, 2:757, 2:797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: 1V -7003.2448915deg
  1:38, 1:78, 1:118, 1:158, 1:198, 1:238, 1:278, 1:318, 1:358, 1:398, 1:438, 1:478, 1:518, 1:558, 1:598, 1:638, 1:678, 1:718, 1:758, 1:798, 1:838, 1:878, 1:918, 1:958, 1:998, 1:1038, 1:1078, 1:1118, 1:1158, 1:1198, 1:1238, 1:1278, 1:1318, 1:1358, 1:1398, 1:1438, 1:1478, 1:1518, 1:1558, 1:1598, 2:38, 2:78, 2:118, 2:158, 2:198, 2:238, 2:278, 2:318, 2:358, 2:398, 2:438, 2:478, 2:518, 2:558, 2:598, 2:638, 2:678, 2:718, 2:758, 2:798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: 1V -7197.77947182deg
  1:39, 1:79, 1:119, 1:159, 1:199, 1:239, 1:279, 1:319, 1:359, 1:399, 1:439, 1:479, 1:519, 1:559, 1:599, 1:639, 1:679, 1:719, 1:759, 1:799, 1:839, 1:879, 1:919, 1:959, 1:999, 1:1039, 1:1079, 1:1119, 1:1159, 1:1199, 1:1239, 1:1279, 1:1319, 1:1359, 1:1399, 1:1439, 1:1479, 1:1519, 1:1559, 1:1599, 2:39, 2:79, 2:119, 2:159, 2:199, 2:239, 2:279, 2:319, 2:359, 2:399, 2:439, 2:479, 2:519, 2:559, 2:599, 2:639, 2:679, 2:719, 2:759, 2:799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: 1V -7392.31405214deg
  1:40, 1:80, 1:120, 1:160, 1:200, 1:240, 1:280, 1:320, 1:360, 1:400, 1:440, 1:480, 1:520, 1:560, 1:600, 1:640, 1:680, 1:720, 1:760, 1:800, 1:840, 1:880, 1:920, 1:960, 1:1000, 1:1040, 1:1080, 1:1120, 1:1160, 1:1200, 1:1240, 1:1280, 1:1320, 1:1360, 1:1400, 1:1440, 1:1480, 1:1520, 1:1560, 1:1600, 2:40, 2:80, 2:120, 2:160, 2:200, 2:240, 2:280, 2:320, 2:360, 2:400, 2:440, 2:480, 2:520, 2:560, 2:600, 2:640, 2:680, 2:720, 2:760, 2:800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: 1V -7586.84863246deg
radiation setups:
  3D: Infinite Sphere Theta=0deg..180deg step 2deg Phi=-180deg..180deg step 2deg
  Azimuth: Infinite Sphere Theta=90deg..90deg step 0deg Phi=-180deg..180deg step 1deg
  Elevation: Infinite Sphere Theta=-180deg..180deg step 1deg Phi=90deg..90deg step 0deg
  Infinite Sphere_3D: Infinite Sphere Theta=0deg..180deg step 2deg Phi=0deg..360deg step 2deg
reports:
  Gain Plot 1: dB(GainTotal) vs Phi, Theta on Setup1 : LastAdaptive, 3D [Freq=4.5GHz]
